# Ansys Electronics Desktop project, version 2025.1
project variables:
  $osd = 207mm
  $dss = 52mm
  $dsy = 7.3mm
  $isd = 101mm
  $wss = 13mm
  $hs0 = 3mm
  $bs0 = 5mm
  $tta = 15deg
  $hs1 = $hs0+($wss-$bs0)*tan($tta)/2
  $papert = 0.5mm
  $bw0 = 2mm
  $wcc = ($wss-2*$papert-$bw0)/2
  $ns = 18
  $alpha_s = 360deg/$ns
  $dc = $dss - $hs1 - 2*$papert
  $g = 1.1mm
  $p = 20
  $alpha_p = 360deg/$p
  $bm0 = 4mm
  $dm = 6.6mm
  $t = 1.5mm
  $ord = $osd+2*$t
  $ird = $isd-2*$t
  $dm0 = 1mm
  $dry = 6.393mm
  $paddingSize = 30
  $d = 154mm
  $wst = (pi*$ad - $ns*$wss)/$ns
  $ntc = 10
  $ad = ($isd+$osd)/2
  $lstk = ($osd-$isd)/2
  $L_axial = $dss+$dsy+$g+$dm+$dry
  $iph_rms = 11.12A
  $wm = (pi*$ad -$p*$bm0)/$p
materials:
  vacuum: permittivity=1
  copper: permeability=0.999991 conductivity=58000000
  steel_1010: permittivity=1 permeability{HUnit=A_per_meter BUnit=tesla curve (0, 0) (238.7, 0.2003) (318.3, 0.3204) (358.1, 0.40045) (437.7, 0.50055) (477.5, 0.5606) (636.6, 0.7908) (795.8, 0.931) (1114.1, 1.1014) (1273.2, 1.2016) (1591.5, 1.302) (2228.2, 1.4028) (3183.1, 1.524) (4774.6, 1.626) (6366.2, 1.698) (7957.7, 1.73) (15915.5, 1.87) (31831, 1.99) (47746.5, 2.04) (63662, 2.07) (79577.5, 2.095) (159155, 2.2) (318310, 2.4)} conductivity=2000000 lande_g_factor=2
  Cogent Power - M330-35A, B-H at 50Hz: CoordinateSystemType=Cylindrical core_loss_curve{50Hz (0, 0) (0.05, 0.01) (0.1, 0.02) (0.15, 0.05) (0.2, 0.08) (0.25, 0.125) (0.3, 0.17) (0.35, 0.225) (0.4, 0.28) (0.45, 0.34) (0.5, 0.4) (0.55, 0.465) (0.6, 0.53) (0.65, 0.605) (0.7, 0.68) (0.75, 0.76) (0.8, 0.84) (0.85, 0.93) (0.9, 1.02) (0.95, 1.12) (1, 1.22) (1.05, 1.33) (1.1, 1.44) (1.15, 1.565) (1.2, 1.69) (1.25, 1.845) (1.3, 2) (1.35, 2.2) (1.4, 2.4) (1.45, 2.67) (1.5, 2.94) (1.55, 3.305) (1.6, 3.67) (1.65, 3.995) (1.7, 4.32) (1.75, 4.525) (1.8, 4.73)} core_loss_curve{100Hz (0, 0) (0.05, 0.025) (0.1, 0.05) (0.15, 0.125) (0.2, 0.2) (0.25, 0.305) (0.3, 0.41) (0.35, 0.54) (0.4, 0.67) (0.45, 0.82) (0.5, 0.97) (0.55, 1.135) (0.6, 1.3) (0.65, 1.49) (0.7, 1.68) (0.75, 1.89) (0.8, 2.1) (0.85, 2.33) (0.9, 2.56) (0.95, 2.815) (1, 3.07) (1.05, 3.355) (1.1, 3.64) (1.15, 3.965) (1.2, 4.29) (1.25, 4.68) (1.3, 5.07) (1.35, 5.565) (1.4, 6.06) (1.45, 6.73) (1.5, 7.4) (1.55, 8.13) (1.6, 8.86) (1.65, 9.59) (1.7, 10.32) (1.75, 11.05) (1.8, 11.78)} core_loss_curve{200Hz (0, 0) (0.05, 0.06) (0.1, 0.12) (0.15, 0.3) (0.2, 0.48) (0.25, 0.75) (0.3, 1.02) (0.35, 1.35) (0.4, 1.68) (0.45, 2.075) (0.5, 2.47) (0.55, 2.92) (0.6, 3.37) (0.65, 3.88) (0.7, 4.39) (0.75, 4.965) (0.8, 5.54) (0.85, 6.18) (0.9, 6.82) (0.95, 7.535) (1, 8.25) (1.05, 9.055) (1.1, 9.86) (1.15, 10.73) (1.2, 11.6) (1.25, 12.65) (1.3, 13.7) (1.35, 15) (1.4, 16.3) (1.45, 17.95) (1.5, 19.6) (1.55, 21.4) (1.6, 23.2) (1.65, 25) (1.7, 26.8) (1.75, 28.6) (1.8, 30.4)} core_loss_curve{400Hz (0, 0) (0.05, 0.165) (0.1, 0.33) (0.15, 0.8) (0.2, 1.27) (0.25, 1.98) (0.3, 2.69) (0.35, 3.59) (0.4, 4.49) (0.45, 5.575) (0.5, 6.66) (0.55, 7.925) (0.6, 9.19) (0.65, 10.65) (0.7, 12.11) (0.75, 13.775) (0.8, 15.44) (0.85, 17.33) (0.9, 19.22) (0.95, 21.38) (1, 23.54) (1.05, 26.01) (1.1, 28.48) (1.15, 31.3) (1.2, 34.12) (1.25, 37.37) (1.3, 40.62) (1.35, 44.43) (1.4, 48.24) (1.45, 53.05) (1.5, 57.86) (1.55, 64.05) (1.6, 70.24) (1.65, 76.43) (1.7, 82.62) (1.75, 88.81) (1.8, 95)} core_loss_curve{1000Hz (0, 0) (0.05, 0.715) (0.1, 1.43) (0.15, 3.415) (0.2, 5.4) (0.25, 8.2) (0.3, 11) (0.35, 14.65) (0.4, 18.3) (0.45, 22.75) (0.5, 27.2) (0.55, 32.65) (0.6, 38.1) (0.65, 44.6) (0.7, 51.1) (0.75, 58.75) (0.8, 66.4) (0.85, 75.45) (0.9, 84.5) (0.95, 95.25) (1, 106) (1.05, 118) (1.1, 130) (1.15, 144.5) (1.2, 159) (1.25, 176) (1.3, 193) (1.35, 213) (1.4, 233) (1.45, 256) (1.5, 279) (1.55, 307) (1.6, 335) (1.65, 363) (1.7, 391) (1.75, 419) (1.8, 447)} permeability{HUnit=A_per_meter BUnit=tesla curve (0, 0) (5, 0.0081679) (10, 0.0177692) (15, 0.029216) (25, 0.0581178) (33.4, 0.1) (43.6, 0.2) (50.8, 0.3) (57.2, 0.4) (63.6, 0.5) (70.4, 0.6) (78.1, 0.7) (87.2, 0.8) (98.7, 0.9) (114, 1) (136, 1.1) (172, 1.2) (242, 1.3) (428, 1.4) (1027, 1.5) (2576, 1.6) (5409, 1.7) (9677, 1.8) (18943, 1.9166) (37081, 1.993) (72586, 2.065) (142090, 2.1664) (278140, 2.3445) (544460, 2.6828) (1065800, 3.3398)} conductivity=2380950 core_loss_type="Electrical Steel" core_loss_kh=160.89 core_loss_kc=0.825387 mass_density=7650 stacking_type=Lamination stacking_factor=0.95 stacking_direction=V(1) core_loss_es_y=1.74124
  Arnold - N38: permeability{HUnit=A_per_meter BUnit=tesla IsTemperatureDependent Temperatures{Temperature{TempRef=-40cel} Temperature{TempRef=20cel} Temperature{TempRef=60cel} Temperature{TempRef=80cel} Temperature{TempRef=100cel} Temperature{TempRef=120cel}} curve (-934500, 0) (-467250, 0.6275) (0, 1.255)} conductivity=555556 magnetic_coercivity{Magnitude=-934500A_per_meter DirComp1=1 DirComp2=0 DirComp3=0}
  Cogent Power - M330-35A, B-H at 50Hz - 2d: core_loss_curve{50Hz (0, 0) (0.05, 0.01) (0.1, 0.02) (0.15, 0.05) (0.2, 0.08) (0.25, 0.125) (0.3, 0.17) (0.35, 0.225) (0.4, 0.28) (0.45, 0.34) (0.5, 0.4) (0.55, 0.465) (0.6, 0.53) (0.65, 0.605) (0.7, 0.68) (0.75, 0.76) (0.8, 0.84) (0.85, 0.93) (0.9, 1.02) (0.95, 1.12) (1, 1.22) (1.05, 1.33) (1.1, 1.44) (1.15, 1.565) (1.2, 1.69) (1.25, 1.845) (1.3, 2) (1.35, 2.2) (1.4, 2.4) (1.45, 2.67) (1.5, 2.94) (1.55, 3.305) (1.6, 3.67) (1.65, 3.995) (1.7, 4.32) (1.75, 4.525) (1.8, 4.73)} core_loss_curve{100Hz (0, 0) (0.05, 0.025) (0.1, 0.05) (0.15, 0.125) (0.2, 0.2) (0.25, 0.305) (0.3, 0.41) (0.35, 0.54) (0.4, 0.67) (0.45, 0.82) (0.5, 0.97) (0.55, 1.135) (0.6, 1.3) (0.65, 1.49) (0.7, 1.68) (0.75, 1.89) (0.8, 2.1) (0.85, 2.33) (0.9, 2.56) (0.95, 2.815) (1, 3.07) (1.05, 3.355) (1.1, 3.64) (1.15, 3.965) (1.2, 4.29) (1.25, 4.68) (1.3, 5.07) (1.35, 5.565) (1.4, 6.06) (1.45, 6.73) (1.5, 7.4) (1.55, 8.13) (1.6, 8.86) (1.65, 9.59) (1.7, 10.32) (1.75, 11.05) (1.8, 11.78)} core_loss_curve{200Hz (0, 0) (0.05, 0.06) (0.1, 0.12) (0.15, 0.3) (0.2, 0.48) (0.25, 0.75) (0.3, 1.02) (0.35, 1.35) (0.4, 1.68) (0.45, 2.075) (0.5, 2.47) (0.55, 2.92) (0.6, 3.37) (0.65, 3.88) (0.7, 4.39) (0.75, 4.965) (0.8, 5.54) (0.85, 6.18) (0.9, 6.82) (0.95, 7.535) (1, 8.25) (1.05, 9.055) (1.1, 9.86) (1.15, 10.73) (1.2, 11.6) (1.25, 12.65) (1.3, 13.7) (1.35, 15) (1.4, 16.3) (1.45, 17.95) (1.5, 19.6) (1.55, 21.4) (1.6, 23.2) (1.65, 25) (1.7, 26.8) (1.75, 28.6) (1.8, 30.4)} core_loss_curve{400Hz (0, 0) (0.05, 0.165) (0.1, 0.33) (0.15, 0.8) (0.2, 1.27) (0.25, 1.98) (0.3, 2.69) (0.35, 3.59) (0.4, 4.49) (0.45, 5.575) (0.5, 6.66) (0.55, 7.925) (0.6, 9.19) (0.65, 10.65) (0.7, 12.11) (0.75, 13.775) (0.8, 15.44) (0.85, 17.33) (0.9, 19.22) (0.95, 21.38) (1, 23.54) (1.05, 26.01) (1.1, 28.48) (1.15, 31.3) (1.2, 34.12) (1.25, 37.37) (1.3, 40.62) (1.35, 44.43) (1.4, 48.24) (1.45, 53.05) (1.5, 57.86) (1.55, 64.05) (1.6, 70.24) (1.65, 76.43) (1.7, 82.62) (1.75, 88.81) (1.8, 95)} core_loss_curve{1000Hz (0, 0) (0.05, 0.715) (0.1, 1.43) (0.15, 3.415) (0.2, 5.4) (0.25, 8.2) (0.3, 11) (0.35, 14.65) (0.4, 18.3) (0.45, 22.75) (0.5, 27.2) (0.55, 32.65) (0.6, 38.1) (0.65, 44.6) (0.7, 51.1) (0.75, 58.75) (0.8, 66.4) (0.85, 75.45) (0.9, 84.5) (0.95, 95.25) (1, 106) (1.05, 118) (1.1, 130) (1.15, 144.5) (1.2, 159) (1.25, 176) (1.3, 193) (1.35, 213) (1.4, 233) (1.45, 256) (1.5, 279) (1.55, 307) (1.6, 335) (1.65, 363) (1.7, 391) (1.75, 419) (1.8, 447)} permeability{HUnit=A_per_meter BUnit=tesla curve (0, 0) (5, 0.0081679) (10, 0.0177692) (15, 0.029216) (25, 0.0581178) (33.4, 0.1) (43.6, 0.2) (50.8, 0.3) (57.2, 0.4) (63.6, 0.5) (70.4, 0.6) (78.1, 0.7) (87.2, 0.8) (98.7, 0.9) (114, 1) (136, 1.1) (172, 1.2) (242, 1.3) (428, 1.4) (1027, 1.5) (2576, 1.6) (5409, 1.7) (9677, 1.8) (18943, 1.9166) (37081, 1.993) (72586, 2.065) (142090, 2.1664) (278140, 2.3445) (544460, 2.6828) (1065800, 3.3398)} conductivity=2380950 core_loss_type="Electrical Steel" core_loss_kh=160.89 core_loss_kc=0.825387 mass_density=7650 stacking_type=Lamination stacking_factor=0.95 stacking_direction=V(3) core_loss_es_y=1.74124

design magnetic loading (Maxwell 3D, Magnetostatic, model units mm)
geometry:
  stator [Cogent Power - M330-35A, B-H at 50Hz] = cylinder(axis=Z, base_centre=(0mm, 0mm, 0mm), radius=$osd/2, height=$dss+$dsy)
  Cylinder2 = cylinder(axis=Z, base_centre=(0mm, 0mm, -10mm), radius=$isd/2, height=$dsy+$dss+20mm)
  stator.subtract(Cylinder2)
  Polyline1 = polyline(x=0mm, yz: (0mm, $dsy) ($wss/2, $dsy) ($wss/2, $dsy+$dss-$hs1) ($bs0/2, $dsy+$dss-$hs0) ($bs0/2, $dsy+$dss+10mm) (0, $dsy+$dss+10mm) (0mm, $dsy), closed, covered)
  Polyline1_1 = Polyline1.duplicate_mirror(point=(0mm, 0mm, 7mm), normal=(0mm, -1mm, 0mm))
  Polyline1.unite(Polyline1_1)
  Polyline1.sweep_along_vector(($osd, 0mm, 0mm))
  Polyline1_2..Polyline1_18 = Polyline1.duplicate_around_axis(axis=Z, angle=(360/18) deg, total=18)
  stator.subtract(Polyline1)
  stator.subtract(Polyline1_10..Polyline1_18, Polyline1_2..Polyline1_9)
  Circle1 = circle(normal=Z, centre=(0mm, 0mm, 0mm), radius=$osd/2+$papert+$wcc)
  Circle2 = circle(normal=Z, centre=(0mm, 0mm, 0mm), radius=$osd/2+$papert)
  Circle1.subtract(Circle2)
  Circle3 = circle(normal=Z, centre=(0mm, 0mm, 0mm), radius=$isd/2-$papert)
  Circle4 = circle(normal=Z, centre=(0mm, 0mm, 0mm), radius=$isd/2 -$papert -$wcc)
  Circle3.subtract(Circle4)
  Polyline2 = polyline(z=0mm, xy: (0mm, 0mm) ($osd, 0mm) (206.2123mm, 18.041239mm) (203.8552mm, 35.945173mm) (0mm, 0mm), closed, covered, AngularArc from point 1 over 3 centre=(0mm, 0mm, 0mm) angle=$alpha_s/2 plane=XY)
  coil_1 [copper] = Polyline2.duplicate_mirror(point=(0mm, 0mm, 0mm), normal=(0mm, -1mm, 0mm))
  coil_1.mirror(point=(0mm, 0mm, 0mm), normal=(0mm, 1mm, 0mm))
  Polyline2.intersect(Circle1)
  coil_1.intersect(Circle3)
  Rectangle1 = rectangle(corner=(0mm, 0mm, 0mm), x_size=$osd, y_size=$wcc + $bw0/2)
  Circle5 = circle(normal=Z, centre=(0mm, 0mm, 0mm), radius=$isd/2+$papert-$wcc)
  Circle6 = circle(normal=Z, centre=(0mm, 0mm, 0mm), radius=$osd/2+$papert+$wcc)
  Rectangle1.intersect(Circle6)
  Rectangle1.subtract(Circle5)
  coil_1.unite(Rectangle1, Polyline2)
  Rectangle2 = rectangle(corner=(0mm, -$bw0/2, 0mm), x_size=$osd, y_size=$bw0)
  coil_1.subtract(Rectangle2)
  coil_1.move(0mm, 0mm, $dsy+$papert)
  coil_1.sweep_along_vector((0mm, 0mm, $dc))
  coil_1.fillet(Edges=coil_1.edge(at (44.9889, 1, 31.2641)) Radius=$wcc/2 Setback=0mm)
  Polyline2_1_1 = coil_1.duplicate_mirror(point=(0mm, 0mm, 0mm), normal=(-sin($alpha_s/2), cos($alpha_s/2), 0mm))
  coil_1.unite(Polyline2_1_1)
  coordinate_system RelativeCS1 = origin=(0mm, 0mm, $dss+$dsy+$g) x=(1mm, 0mm, 0mm) y=(0mm, 1mm, 0mm)
  coordinate_system north_CS = origin=(0mm, 0mm, 0mm) x=(0mm, 0mm, -1mm) y=(0mm, 1mm, 0mm)
  magnet_1 [Arnold - N38, oriented by north_CS] = polyline(z=0mm, xy: (0mm, 0mm) ($osd/2, 0mm) (102.22574mm, 16.190967mm) (98.434349mm, 31.983259mm) (0mm, 0mm), closed, covered, AngularArc from point 1 over 3 centre=(0mm, 0mm, 0mm) angle=$alpha_p plane=XY) in RelativeCS1
  Circle7 = circle(normal=Z, centre=(0mm, 0mm, 0mm), radius=$isd/2) in RelativeCS1
  magnet_1.subtract(Circle7)
  Rectangle3 = rectangle(corner=(0mm, -$bm0/2, 0mm), x_size=$osd, y_size=$bm0) in RelativeCS1
  Rectangle3.duplicate_around_axis(axis=Z, angle=$alpha_p, total=2, attached) in RelativeCS1
  magnet_1.subtract(Rectangle3)
  magnet_1.sweep_along_vector((0mm, 0mm, $dm)) in RelativeCS1
  magnet_2 [Arnold - N38, oriented by South_CS], magnet_3 [Arnold - N38, oriented by north_CS], magnet_4 [Arnold - N38, oriented by South_CS], magnet_5 [Arnold - N38, oriented by north_CS], magnet_6 [Arnold - N38, oriented by South_CS], magnet_7 [Arnold - N38, oriented by north_CS], magnet_8 [Arnold - N38, oriented by South_CS], magnet_9 [Arnold - N38, oriented by north_CS], magnet_10 [Arnold - N38, oriented by South_CS], magnet_11 [Arnold - N38, oriented by north_CS], magnet_12 [Arnold - N38, oriented by South_CS], magnet_13 [Arnold - N38, oriented by north_CS], magnet_14 [Arnold - N38, oriented by South_CS], magnet_15 [Arnold - N38, oriented by north_CS], magnet_16 [Arnold - N38, oriented by South_CS], magnet_17 [Arnold - N38, oriented by north_CS], magnet_18 [Arnold - N38, oriented by South_CS], magnet_19 [Arnold - N38, oriented by north_CS], magnet_20 [Arnold - N38, oriented by South_CS] = magnet_1.duplicate_around_axis(axis=Z, angle=$alpha_p, total=20) in RelativeCS1
  coordinate_system South_CS = origin=(0mm, 0mm, 0mm) x=(0mm, 0mm, 1mm) y=(0mm, 1mm, 0mm)
  coil_1_1..coil_1_17 [copper] = coil_1.duplicate_around_axis(axis=Z, angle=360deg/18, total=18)
  Circle8 = circle(normal=Z, centre=(0mm, 0mm, $dm-$dm0), radius=$ird/2) in RelativeCS1
  rotor [steel_1010] = circle(normal=Z, centre=(0mm, 0mm, $dm-$dm0), radius=$ord/2) in RelativeCS1
  rotor.subtract(Circle8)
  rotor.sweep_along_vector((0mm, 0mm, $dm0+$dry)) in RelativeCS1
  magnet_1_1 = magnet_1.copy()
  magnet_10_1 = magnet_10.copy()
  magnet_11_1 = magnet_11.copy()
  magnet_12_1 = magnet_12.copy()
  magnet_13_1 = magnet_13.copy()
  magnet_14_1 = magnet_14.copy()
  magnet_15_1 = magnet_15.copy()
  magnet_16_1 = magnet_16.copy()
  magnet_17_1 = magnet_17.copy()
  magnet_18_1 = magnet_18.copy()
  magnet_19_1 = magnet_19.copy()
  magnet_2_1 = magnet_2.copy()
  magnet_20_1 = magnet_20.copy()
  magnet_3_1 = magnet_3.copy()
  magnet_4_1 = magnet_4.copy()
  magnet_5_1 = magnet_5.copy()
  magnet_6_1 = magnet_6.copy()
  magnet_7_1 = magnet_7.copy()
  magnet_8_1 = magnet_8.copy()
  magnet_9_1 = magnet_9.copy()
  rotor.subtract(magnet_1_1, magnet_10_1, magnet_11_1, magnet_12_1, magnet_13_1, magnet_14_1, magnet_15_1, magnet_16_1, magnet_17_1, magnet_18_1, magnet_19_1, magnet_2_1, magnet_20_1, magnet_3_1, magnet_4_1, magnet_5_1, magnet_6_1, magnet_7_1, magnet_8_1, magnet_9_1)
  Region [vacuum] = region(percentage_offset: +X=$paddingSize, -X=$paddingSize, +Y=$paddingSize, -Y=$paddingSize, +Z=2*$paddingSize, -Z=2*$paddingSize)
  Circle9 = circle(normal=Z, centre=(0mm, 0mm, -$g/2), radius=$isd/2) in RelativeCS1
  AG_surface = circle(normal=Z, centre=(0mm, 0mm, -$g/2), radius=$osd/2) in RelativeCS1
  AG_surface.subtract(Circle9)
  ccs_surface [vacuum] = circle(normal=Z, centre=(0mm, 0mm, -5mm), radius=$d/2)
  ccs_surface.sweep_along_vector((0mm, 0mm, $L_axial+10mm))
mesh:
  initial mesh: GlobalCurvilinear{Apply}
setups:
  Setup1: Magnetostatic MaximumPasses=10 MinimumPasses=2 MinimumConvergedPasses=1 PercentRefinement=30 PercentError=1 NonLinearResidual=0.001
field plots:
  Mesh1: MeshPlots in stator, coil_1, magnet_1..magnet_20, coil_1_1..coil_1_17, rotor on Setup1 : LastAdaptive
  B_Vector1: B in stator, coil_1, magnet_1..magnet_20, coil_1_1..coil_1_17, rotor, Region on Setup1 : LastAdaptive

design transients (Maxwell 3D, Transient, model units mm)
geometry:
  stator [Cogent Power - M330-35A, B-H at 50Hz] = cylinder(axis=Z, base_centre=(0mm, 0mm, 0mm), radius=$osd/2, height=$dss+$dsy)
  Cylinder2 = cylinder(axis=Z, base_centre=(0mm, 0mm, -10mm), radius=$isd/2, height=$dsy+$dss+20mm)
  stator.subtract(Cylinder2)
  Polyline1 = polyline(x=0mm, yz: (0mm, $dsy) ($wss/2, $dsy) ($wss/2, $dsy+$dss-$hs1) ($bs0/2, $dsy+$dss-$hs0) ($bs0/2, $dsy+$dss+10mm) (0, $dsy+$dss+10mm) (0mm, $dsy), closed, covered)
  Polyline1_1 = Polyline1.duplicate_mirror(point=(0mm, 0mm, 7mm), normal=(0mm, -1mm, 0mm))
  Polyline1.unite(Polyline1_1)
  Polyline1.sweep_along_vector(($osd, 0mm, 0mm))
  Polyline1_2..Polyline1_18 = Polyline1.duplicate_around_axis(axis=Z, angle=(360/18) deg, total=18)
  stator.subtract(Polyline1)
  stator.subtract(Polyline1_10..Polyline1_18, Polyline1_2..Polyline1_9)
  Circle1 = circle(normal=Z, centre=(0mm, 0mm, 0mm), radius=$osd/2+$papert+$wcc)
  Circle2 = circle(normal=Z, centre=(0mm, 0mm, 0mm), radius=$osd/2+$papert)
  Circle1.subtract(Circle2)
  Circle3 = circle(normal=Z, centre=(0mm, 0mm, 0mm), radius=$isd/2-$papert)
  Circle4 = circle(normal=Z, centre=(0mm, 0mm, 0mm), radius=$isd/2 -$papert -$wcc)
  Circle3.subtract(Circle4)
  Polyline2 = polyline(z=0mm, xy: (0mm, 0mm) ($osd, 0mm) (206.2123mm, 18.041239mm) (203.8552mm, 35.945173mm) (0mm, 0mm), closed, covered, AngularArc from point 1 over 3 centre=(0mm, 0mm, 0mm) angle=$alpha_s/2 plane=XY)
  coil_1 [copper] = Polyline2.duplicate_mirror(point=(0mm, 0mm, 0mm), normal=(0mm, -1mm, 0mm))
  coil_1.mirror(point=(0mm, 0mm, 0mm), normal=(0mm, 1mm, 0mm))
  Polyline2.intersect(Circle1)
  coil_1.intersect(Circle3)
  Rectangle1 = rectangle(corner=(0mm, 0mm, 0mm), x_size=$osd, y_size=$wcc + $bw0/2)
  Circle5 = circle(normal=Z, centre=(0mm, 0mm, 0mm), radius=$isd/2+$papert-$wcc)
  Circle6 = circle(normal=Z, centre=(0mm, 0mm, 0mm), radius=$osd/2+$papert+$wcc)
  Rectangle1.intersect(Circle6)
  Rectangle1.subtract(Circle5)
  coil_1.unite(Rectangle1, Polyline2)
  Rectangle2 = rectangle(corner=(0mm, -$bw0/2, 0mm), x_size=$osd, y_size=$bw0)
  coil_1.subtract(Rectangle2)
  coil_1.move(0mm, 0mm, $dsy+$papert)
  coil_1.sweep_along_vector((0mm, 0mm, $dc))
  coil_1.fillet(Edges=coil_1.edge(at (44.9889, 1, 31.2641)) Radius=$wcc/2 Setback=0mm)
  Polyline2_1_1 = coil_1.duplicate_mirror(point=(0mm, 0mm, 0mm), normal=(-sin($alpha_s/2), cos($alpha_s/2), 0mm))
  coil_1.unite(Polyline2_1_1)
  coordinate_system RelativeCS1 = origin=(0mm, 0mm, $dss+$dsy+$g) x=(1mm, 0mm, 0mm) y=(0mm, 1mm, 0mm)
  coordinate_system north_CS = origin=(0mm, 0mm, 0mm) x=(0mm, 0mm, -1mm) y=(0mm, 1mm, 0mm)
  magnet_1 [Arnold - N38, oriented by north_CS] = polyline(z=0mm, xy: (0mm, 0mm) ($osd/2, 0mm) (102.22574mm, 16.190967mm) (98.434349mm, 31.983259mm) (0mm, 0mm), closed, covered, AngularArc from point 1 over 3 centre=(0mm, 0mm, 0mm) angle=$alpha_p plane=XY) in RelativeCS1
  Circle7 = circle(normal=Z, centre=(0mm, 0mm, 0mm), radius=$isd/2) in RelativeCS1
  magnet_1.subtract(Circle7)
  Rectangle3 = rectangle(corner=(0mm, -$bm0/2, 0mm), x_size=$osd, y_size=$bm0) in RelativeCS1
  Rectangle3.duplicate_around_axis(axis=Z, angle=$alpha_p, total=2, attached) in RelativeCS1
  magnet_1.subtract(Rectangle3)
  magnet_1.sweep_along_vector((0mm, 0mm, $dm)) in RelativeCS1
  magnet_2 [Arnold - N38, oriented by South_CS], magnet_3 [Arnold - N38, oriented by north_CS], magnet_4 [Arnold - N38, oriented by South_CS], magnet_5 [Arnold - N38, oriented by north_CS], magnet_6 [Arnold - N38, oriented by South_CS], magnet_7 [Arnold - N38, oriented by north_CS], magnet_8 [Arnold - N38, oriented by South_CS], magnet_9 [Arnold - N38, oriented by north_CS], magnet_10 [Arnold - N38, oriented by South_CS], magnet_11 [Arnold - N38, oriented by north_CS], magnet_12 [Arnold - N38, oriented by South_CS], magnet_13 [Arnold - N38, oriented by north_CS], magnet_14 [Arnold - N38, oriented by South_CS], magnet_15 [Arnold - N38, oriented by north_CS], magnet_16 [Arnold - N38, oriented by South_CS], magnet_17 [Arnold - N38, oriented by north_CS], magnet_18 [Arnold - N38, oriented by South_CS], magnet_19 [Arnold - N38, oriented by north_CS], magnet_20 [Arnold - N38, oriented by South_CS] = magnet_1.duplicate_around_axis(axis=Z, angle=$alpha_p, total=20) in RelativeCS1
  coordinate_system South_CS = origin=(0mm, 0mm, 0mm) x=(0mm, 0mm, -1mm) y=(0mm, 1mm, 0mm)
  coil_2..coil_18 [copper] = coil_1.duplicate_around_axis(axis=Z, angle=360deg/18, total=18)
  Circle8 = circle(normal=Z, centre=(0mm, 0mm, $dm-$dm0), radius=$ird/2) in RelativeCS1
  rotor [steel_1010] = circle(normal=Z, centre=(0mm, 0mm, $dm-$dm0), radius=$ord/2) in RelativeCS1
  rotor.subtract(Circle8)
  rotor.sweep_along_vector((0mm, 0mm, $dm0+$dry)) in RelativeCS1
  magnet_1_1 = magnet_1.copy()
  magnet_10_1 = magnet_10.copy()
  magnet_11_1 = magnet_11.copy()
  magnet_12_1 = magnet_12.copy()
  magnet_13_1 = magnet_13.copy()
  magnet_14_1 = magnet_14.copy()
  magnet_15_1 = magnet_15.copy()
  magnet_16_1 = magnet_16.copy()
  magnet_17_1 = magnet_17.copy()
  magnet_18_1 = magnet_18.copy()
  magnet_19_1 = magnet_19.copy()
  magnet_2_1 = magnet_2.copy()
  magnet_20_1 = magnet_20.copy()
  magnet_3_1 = magnet_3.copy()
  magnet_4_1 = magnet_4.copy()
  magnet_5_1 = magnet_5.copy()
  magnet_6_1 = magnet_6.copy()
  magnet_7_1 = magnet_7.copy()
  magnet_8_1 = magnet_8.copy()
  magnet_9_1 = magnet_9.copy()
  rotor.subtract(magnet_1_1, magnet_10_1, magnet_11_1, magnet_12_1, magnet_13_1, magnet_14_1, magnet_15_1, magnet_16_1, magnet_17_1, magnet_18_1, magnet_19_1, magnet_2_1, magnet_20_1, magnet_3_1, magnet_4_1, magnet_5_1, magnet_6_1, magnet_7_1, magnet_8_1, magnet_9_1)
  Region [vacuum] = region(percentage_offset: +X=$paddingSize, -X=$paddingSize, +Y=$paddingSize, -Y=$paddingSize, +Z=2*$paddingSize, -Z=2*$paddingSize)
  motion_band [vacuum] = cylinder(axis=Z, base_centre=(0mm, 0mm, -$g/2), radius=$osd/2+10mm, height=$g+$dm+$dry+5mm) in RelativeCS1
  coordinate_system RelativeCS2 = origin=(0mm, 0mm, 0mm) x=(cos($alpha_s/2), sin($alpha_s/2), 0mm) y=(-sin($alpha_s/2), cos($alpha_s/2), 0mm)
  coilinput_1 [copper] = coil_1.section(plane=ZX) in RelativeCS2
  coilinput_1.separate_bodies()
  coilinput_2, coilinput_18, coilinput_3..coilinput_17 [copper] = coilinput_1.duplicate_around_axis(axis=Z, angle=360deg/18, total=18)
  Circle9 = circle(normal=Z, centre=(0mm, 0mm, -$g/2), radius=$isd/2) in RelativeCS1
  AG_surface = circle(normal=Z, centre=(0mm, 0mm, -$g/2), radius=$osd/2) in RelativeCS1
  AG_surface.subtract(Circle9)
  Circle10 [vacuum, non-model] = circle(normal=Z, centre=(0mm, 0mm, -5mm), radius=$d/2)
  Circle10.sweep_along_vector((0mm, 0mm, $L_axial+10mm))
motion:
  MotionSetup1: Band Move_Type=Rotate Coordinate_System=Global Axis=Z Is_Positive=true InitPos=0deg Angular_Velocity=750rpm Objects=motion_band
  Moving1: Moving Objects=[magnet_1..magnet_20, rotor]
boundaries and excitations:
  coilinput_1: Coil Terminal Objects=coilinput_1 Conductor_number=$Ntc Winding=phaseA Point_out_of_terminal=true
  coilinput_2: Coil Terminal Objects=coilinput_2 Conductor_number=$Ntc Winding=phaseA Point_out_of_terminal=false
  coilinput_10: Coil Terminal Objects=coilinput_10 Conductor_number=$Ntc Winding=phaseA Point_out_of_terminal=true
  coilinput_11: Coil Terminal Objects=coilinput_11 Conductor_number=$Ntc Winding=phaseA Point_out_of_terminal=false
  coilinput_9: Coil Terminal Objects=coilinput_9 Conductor_number=$Ntc Winding=phaseA Point_out_of_terminal=false
  coilinput_18: Coil Terminal Objects=coilinput_18 Conductor_number=$Ntc Winding=phaseA Point_out_of_terminal=false
  coilinput_7: Coil Terminal Objects=coilinput_7 Conductor_number=$Ntc Winding=phaseB Point_out_of_terminal=true
  coilinput_16: Coil Terminal Objects=coilinput_16 Conductor_number=$Ntc Winding=phaseB Point_out_of_terminal=true
  coilinput_8: Coil Terminal Objects=coilinput_8 Conductor_number=$Ntc Winding=phaseB Point_out_of_terminal=false
  coilinput_17: Coil Terminal Objects=coilinput_17 Conductor_number=$Ntc Winding=phaseB Point_out_of_terminal=false
  coilinput_15: Coil Terminal Objects=coilinput_15 Conductor_number=$Ntc Winding=phaseB Point_out_of_terminal=false
  coilinput_6: Coil Terminal Objects=coilinput_6 Conductor_number=$Ntc Winding=phaseB Point_out_of_terminal=false
  coilinput_13: Coil Terminal Objects=coilinput_13 Conductor_number=$Ntc Winding=phaseC Point_out_of_terminal=true
  coilinput_4: Coil Terminal Objects=coilinput_4 Conductor_number=$Ntc Winding=phaseC Point_out_of_terminal=true
  coilinput_3: Coil Terminal Objects=coilinput_3 Conductor_number=$Ntc Winding=phaseC Point_out_of_terminal=false
  coilinput_5: Coil Terminal Objects=coilinput_5 Conductor_number=$Ntc Winding=phaseC Point_out_of_terminal=false
  coilinput_12: Coil Terminal Objects=coilinput_12 Conductor_number=$Ntc Winding=phaseC Point_out_of_terminal=false
  coilinput_14: Coil Terminal Objects=coilinput_14 Conductor_number=$Ntc Winding=phaseC Point_out_of_terminal=false
  phaseA: Winding Group Type=Current IsSolid=false Current=0mA ParallelBranchesNum=1
  phaseB: Winding Group Type=Current IsSolid=false Current=0mA ParallelBranchesNum=1
  phaseC: Winding Group Type=Current IsSolid=false Current=0mA ParallelBranchesNum=1
mesh:
  Length1: LengthBased RefineInside Objects=[coil_1..coil_18] MaxLength=$dc/3
  SurfApprox1: SurfApproxBased Faces=coil_1.face(at (102.42, 18.0594, 31.2641), at (44.3163, 7.81417, 31.2641), at (49.2404, 8.68241, 31.2641), at (76.7327, 6, 31.2641), at (107.344, 18.9277, 31.2641), at (78.1831, 1, 31.2641), at (45.6695, 1.66826, 31.2641), at (74.1573, 20.606, 31.2641), at (73.8101, 25.8005, 31.2641), at (43.4859, 14.0522, 31.2641)) coil_2.face(at (90.0666, 52, 31.2641), at (38.9711, 22.5, 31.2641), at (43.3013, 25, 31.2641), at (70.0531, 31.8823, 31.2641), at (94.3968, 54.5, 31.2641), at (73.1261, 27.6799, 31.2641), at (42.3447, 17.1875, 31.2641), at (62.6374, 44.7266, 31.2641), at (60.5346, 49.4891, 31.2641), at (36.0572, 28.0778, 31.2641)) coil_3.face(at (66.8499, 79.6686, 31.2641), at (28.9254, 34.472, 31.2641), at (32.1394, 38.3022, 31.2641), at (54.924, 53.9191, 31.2641), at (70.0638, 83.4988, 31.2641), at (59.249, 51.0212, 31.2641), at (33.9125, 30.6337, 31.2641), at (43.5625, 63.4525, 31.2641), at (39.9576, 67.2086, 31.2641), at (24.2795, 38.7168, 31.2641)) coil_4.face(at (35.5701, 97.728, 31.2641), at (15.3909, 42.2862, 31.2641), at (17.101, 46.9846, 31.2641), at (33.1702, 69.4525, 31.2641), at (37.2802, 102.426, 31.2641), at (38.2255, 68.2086, 31.2641), at (21.39, 40.3851, 31.2641), at (19.2333, 74.5251, 31.2641), at (14.5612, 76.8217, 31.2641), at (9.57334, 44.686, 31.2641)) coil_5.face(at (0, 104, 31.2641), at (0, 45, 31.2641), at (0, 50, 31.2641), at (7.41565, 76.6089, 31.2641), at (0, 109, 31.2641), at (12.5916, 77.169, 31.2641), at (6.28751, 45.2654, 31.2641), at (-7.41565, 76.6089, 31.2641), at (-12.5916, 77.169, 31.2641), at (-6.28751, 45.2654, 31.2641)) coil_6.face(at (-35.5701, 97.728, 31.2641), at (-15.3909, 42.2862, 31.2641), at (-17.101, 46.9846, 31.2641), at (-19.2333, 74.5251, 31.2641), at (-37.2802, 102.426, 31.2641), at (-14.5612, 76.8217, 31.2641), at (-9.57334, 44.686, 31.2641), at (-33.1702, 69.4525, 31.2641), at (-38.2255, 68.2086, 31.2641), at (-21.39, 40.3851, 31.2641)) coil_7.face(at (-66.8499, 79.6686, 31.2641), at (-28.9254, 34.472, 31.2641), at (-32.1394, 38.3022, 31.2641), at (-43.5625, 63.4525, 31.2641), at (-70.0638, 83.4988, 31.2641), at (-39.9576, 67.2086, 31.2641), at (-24.2795, 38.7168, 31.2641), at (-54.924, 53.9191, 31.2641), at (-59.249, 51.0212, 31.2641), at (-33.9125, 30.6337, 31.2641)) coil_8.face(at (-90.0666, 52, 31.2641), at (-38.9711, 22.5, 31.2641), at (-43.3013, 25, 31.2641), at (-62.6374, 44.7266, 31.2641), at (-94.3968, 54.5, 31.2641), at (-60.5346, 49.4891, 31.2641), at (-36.0572, 28.0778, 31.2641), at (-70.0531, 31.8823, 31.2641), at (-73.1261, 27.6799, 31.2641), at (-42.3447, 17.1875, 31.2641)) coil_9.face(at (-102.42, 18.0594, 31.2641), at (-44.3163, 7.81417, 31.2641), at (-49.2404, 8.68241, 31.2641), at (-74.1573, 20.606, 31.2641), at (-107.344, 18.9277, 31.2641), at (-73.8101, 25.8005, 31.2641), at (-43.4859, 14.0522, 31.2641), at (-76.7327, 6, 31.2641), at (-78.1831, 1, 31.2641), at (-45.6695, 1.66826, 31.2641)) coil_10.face(at (-102.42, -18.0594, 31.2641), at (-44.3163, -7.81417, 31.2641), at (-49.2404, -8.68241, 31.2641), at (-76.7327, -6, 31.2641), at (-107.344, -18.9277, 31.2641), at (-78.1831, -1, 31.2641), at (-45.6695, -1.66826, 31.2641), at (-74.1573, -20.606, 31.2641), at (-73.8101, -25.8005, 31.2641), at (-43.4859, -14.0522, 31.2641)) coil_11.face(at (-90.0666, -52, 31.2641), at (-38.9711, -22.5, 31.2641), at (-43.3013, -25, 31.2641), at (-70.0531, -31.8823, 31.2641), at (-94.3968, -54.5, 31.2641), at (-73.1261, -27.6799, 31.2641), at (-42.3447, -17.1875, 31.2641), at (-62.6374, -44.7266, 31.2641), at (-60.5346, -49.4891, 31.2641), at (-36.0572, -28.0778, 31.2641)) coil_12.face(at (-66.8499, -79.6686, 31.2641), at (-28.9254, -34.472, 31.2641), at (-32.1394, -38.3022, 31.2641), at (-54.924, -53.9191, 31.2641), at (-70.0638, -83.4988, 31.2641), at (-59.249, -51.0212, 31.2641), at (-33.9125, -30.6337, 31.2641), at (-43.5625, -63.4525, 31.2641), at (-39.9576, -67.2086, 31.2641), at (-24.2795, -38.7168, 31.2641)) coil_13.face(at (-35.5701, -97.728, 31.2641), at (-15.3909, -42.2862, 31.2641), at (-17.101, -46.9846, 31.2641), at (-33.1702, -69.4525, 31.2641), at (-37.2802, -102.426, 31.2641), at (-38.2255, -68.2086, 31.2641), at (-21.39, -40.3851, 31.2641), at (-19.2333, -74.5251, 31.2641), at (-14.5612, -76.8217, 31.2641), at (-9.57334, -44.686, 31.2641)) coil_14.face(at (0, -104, 31.2641), at (0, -45, 31.2641), at (0, -50, 31.2641), at (-7.41565, -76.6089, 31.2641), at (0, -109, 31.2641), at (-12.5916, -77.169, 31.2641), at (-6.28751, -45.2654, 31.2641), at (7.41565, -76.6089, 31.2641), at (12.5916, -77.169, 31.2641), at (6.28751, -45.2654, 31.2641)) coil_15.face(at (35.5701, -97.728, 31.2641), at (15.3909, -42.2862, 31.2641), at (17.101, -46.9846, 31.2641), at (19.2333, -74.5251, 31.2641), at (37.2802, -102.426, 31.2641), at (14.5612, -76.8217, 31.2641), at (9.57334, -44.686, 31.2641), at (33.1702, -69.4525, 31.2641), at (38.2255, -68.2086, 31.2641), at (21.39, -40.3851, 31.2641)) coil_16.face(at (66.8499, -79.6686, 31.2641), at (28.9254, -34.472, 31.2641), at (32.1394, -38.3022, 31.2641), at (43.5625, -63.4525, 31.2641), at (70.0638, -83.4988, 31.2641), at (39.9576, -67.2086, 31.2641), at (24.2795, -38.7168, 31.2641), at (54.924, -53.9191, 31.2641), at (59.249, -51.0212, 31.2641), at (33.9125, -30.6337, 31.2641)) coil_17.face(at (90.0666, -52, 31.2641), at (38.9711, -22.5, 31.2641), at (43.3013, -25, 31.2641), at (62.6374, -44.7266, 31.2641), at (94.3968, -54.5, 31.2641), at (60.5346, -49.4891, 31.2641), at (36.0572, -28.0778, 31.2641), at (70.0531, -31.8823, 31.2641), at (73.1261, -27.6799, 31.2641), at (42.3447, -17.1875, 31.2641)) coil_18.face(at (102.42, -18.0594, 31.2641), at (44.3163, -7.81417, 31.2641), at (49.2404, -8.68241, 31.2641), at (74.1573, -20.606, 31.2641), at (107.344, -18.9277, 31.2641), at (73.8101, -25.8005, 31.2641), at (43.4859, -14.0522, 31.2641), at (76.7327, -6, 31.2641), at (78.1831, -1, 31.2641), at (45.6695, -1.66826, 31.2641)) CurvedSurfaceApproxChoice=ManualSettings NormalDev=40deg
  Length2: LengthBased RefineInside Objects=[coil_1..coil_18] MaxLength=$lstk/5
  Length3: LengthBased Objects=AG_surface MaxLength=$lstk/10
  initial mesh: GlobalCurvilinear{Apply}
setups:
  Setup1: Transient NonlinearSolverResidual=0.005 ScalarPotential="Second Order" StopTime=8ms TimeStep=8ms/50
reports:
  Winding Plot1: FluxLinkage(phaseA), FluxLinkage(phaseB), FluxLinkage(phaseC) vs Time on Setup1 : Transient
  Winding Plot2: InducedVoltage(phaseA), InducedVoltage(phaseB), InducedVoltage(phaseC) vs Time on Setup1 : Transient

design magnetic (Maxwell 3D, Magnetostatic, model units mm)
geometry:
  stator [Cogent Power - M330-35A, B-H at 50Hz] = cylinder(axis=Z, base_centre=(0mm, 0mm, 0mm), radius=$osd/2, height=$dss+$dsy)
  Cylinder2 = cylinder(axis=Z, base_centre=(0mm, 0mm, -10mm), radius=$isd/2, height=$dsy+$dss+20mm)
  stator.subtract(Cylinder2)
  Polyline1 = polyline(x=0mm, yz: (0mm, $dsy) ($wss/2, $dsy) ($wss/2, $dsy+$dss-$hs1) ($bs0/2, $dsy+$dss-$hs0) ($bs0/2, $dsy+$dss+10mm) (0, $dsy+$dss+10mm) (0mm, $dsy), closed, covered)
  Polyline1_1 = Polyline1.duplicate_mirror(point=(0mm, 0mm, 7mm), normal=(0mm, -1mm, 0mm))
  Polyline1.unite(Polyline1_1)
  Polyline1.sweep_along_vector(($osd, 0mm, 0mm))
  Polyline1_2..Polyline1_18 = Polyline1.duplicate_around_axis(axis=Z, angle=(360/18) deg, total=18)
  stator.subtract(Polyline1)
  stator.subtract(Polyline1_10..Polyline1_18, Polyline1_2..Polyline1_9)
  Circle1 = circle(normal=Z, centre=(0mm, 0mm, 0mm), radius=$osd/2+$papert+$wcc)
  Circle2 = circle(normal=Z, centre=(0mm, 0mm, 0mm), radius=$osd/2+$papert)
  Circle1.subtract(Circle2)
  Circle3 = circle(normal=Z, centre=(0mm, 0mm, 0mm), radius=$isd/2-$papert)
  Circle4 = circle(normal=Z, centre=(0mm, 0mm, 0mm), radius=$isd/2 -$papert -$wcc)
  Circle3.subtract(Circle4)
  Polyline2 = polyline(z=0mm, xy: (0mm, 0mm) ($osd, 0mm) (206.2123mm, 18.041239mm) (203.8552mm, 35.945173mm) (0mm, 0mm), closed, covered, AngularArc from point 1 over 3 centre=(0mm, 0mm, 0mm) angle=$alpha_s/2 plane=XY)
  coil_1 [copper] = Polyline2.duplicate_mirror(point=(0mm, 0mm, 0mm), normal=(0mm, -1mm, 0mm))
  coil_1.mirror(point=(0mm, 0mm, 0mm), normal=(0mm, 1mm, 0mm))
  Polyline2.intersect(Circle1)
  coil_1.intersect(Circle3)
  Rectangle1 = rectangle(corner=(0mm, 0mm, 0mm), x_size=$osd, y_size=$wcc + $bw0/2)
  Circle5 = circle(normal=Z, centre=(0mm, 0mm, 0mm), radius=$isd/2+$papert-$wcc)
  Circle6 = circle(normal=Z, centre=(0mm, 0mm, 0mm), radius=$osd/2+$papert+$wcc)
  Rectangle1.intersect(Circle6)
  Rectangle1.subtract(Circle5)
  coil_1.unite(Rectangle1, Polyline2)
  Rectangle2 = rectangle(corner=(0mm, -$bw0/2, 0mm), x_size=$osd, y_size=$bw0)
  coil_1.subtract(Rectangle2)
  coil_1.move(0mm, 0mm, $dsy+$papert)
  coil_1.sweep_along_vector((0mm, 0mm, $dc))
  coil_1.fillet(Edges=coil_1.edge(at (44.9889, 1, 31.2641)) Radius=$wcc/2 Setback=0mm)
  Polyline2_1_1 = coil_1.duplicate_mirror(point=(0mm, 0mm, 0mm), normal=(-sin($alpha_s/2), cos($alpha_s/2), 0mm))
  coil_1.unite(Polyline2_1_1)
  coordinate_system RelativeCS1 = origin=(0mm, 0mm, $dss+$dsy+$g) x=(1mm, 0mm, 0mm) y=(0mm, 1mm, 0mm)
  coordinate_system north_CS = origin=(0mm, 0mm, 0mm) x=(0mm, 0mm, -1mm) y=(0mm, 1mm, 0mm)
  magnet_1 [Arnold - N38, oriented by north_CS] = polyline(z=0mm, xy: (0mm, 0mm) ($osd/2, 0mm) (102.22574mm, 16.190967mm) (98.434349mm, 31.983259mm) (0mm, 0mm), closed, covered, AngularArc from point 1 over 3 centre=(0mm, 0mm, 0mm) angle=$alpha_p plane=XY) in RelativeCS1
  Circle7 = circle(normal=Z, centre=(0mm, 0mm, 0mm), radius=$isd/2) in RelativeCS1
  magnet_1.subtract(Circle7)
  Rectangle3 = rectangle(corner=(0mm, -$bm0/2, 0mm), x_size=$osd, y_size=$bm0) in RelativeCS1
  Rectangle3.duplicate_around_axis(axis=Z, angle=$alpha_p, total=2, attached) in RelativeCS1
  magnet_1.subtract(Rectangle3)
  magnet_1.sweep_along_vector((0mm, 0mm, $dm)) in RelativeCS1
  magnet_2 [Arnold - N38, oriented by South_CS], magnet_3 [Arnold - N38, oriented by north_CS], magnet_4 [Arnold - N38, oriented by South_CS], magnet_5 [Arnold - N38, oriented by north_CS], magnet_6 [Arnold - N38, oriented by South_CS], magnet_7 [Arnold - N38, oriented by north_CS], magnet_8 [Arnold - N38, oriented by South_CS], magnet_9 [Arnold - N38, oriented by north_CS], magnet_10 [Arnold - N38, oriented by South_CS], magnet_11 [Arnold - N38, oriented by north_CS], magnet_12 [Arnold - N38, oriented by South_CS], magnet_13 [Arnold - N38, oriented by north_CS], magnet_14 [Arnold - N38, oriented by South_CS], magnet_15 [Arnold - N38, oriented by north_CS], magnet_16 [Arnold - N38, oriented by South_CS], magnet_17 [Arnold - N38, oriented by north_CS], magnet_18 [Arnold - N38, oriented by South_CS], magnet_19 [Arnold - N38, oriented by north_CS], magnet_20 [Arnold - N38, oriented by South_CS] = magnet_1.duplicate_around_axis(axis=Z, angle=$alpha_p, total=20) in RelativeCS1
  coordinate_system South_CS = origin=(0mm, 0mm, 0mm) x=(0mm, 0mm, 1mm) y=(0mm, 1mm, 0mm)
  coil_2..coil_18 [copper] = coil_1.duplicate_around_axis(axis=Z, angle=360deg/18, total=18)
  Circle8 = circle(normal=Z, centre=(0mm, 0mm, $dm-$dm0), radius=$ird/2) in RelativeCS1
  rotor [steel_1010] = circle(normal=Z, centre=(0mm, 0mm, $dm-$dm0), radius=$ord/2) in RelativeCS1
  rotor.subtract(Circle8)
  rotor.sweep_along_vector((0mm, 0mm, $dm0+$dry)) in RelativeCS1
  magnet_1_1 = magnet_1.copy()
  magnet_10_1 = magnet_10.copy()
  magnet_11_1 = magnet_11.copy()
  magnet_12_1 = magnet_12.copy()
  magnet_13_1 = magnet_13.copy()
  magnet_14_1 = magnet_14.copy()
  magnet_15_1 = magnet_15.copy()
  magnet_16_1 = magnet_16.copy()
  magnet_17_1 = magnet_17.copy()
  magnet_18_1 = magnet_18.copy()
  magnet_19_1 = magnet_19.copy()
  magnet_2_1 = magnet_2.copy()
  magnet_20_1 = magnet_20.copy()
  magnet_3_1 = magnet_3.copy()
  magnet_4_1 = magnet_4.copy()
  magnet_5_1 = magnet_5.copy()
  magnet_6_1 = magnet_6.copy()
  magnet_7_1 = magnet_7.copy()
  magnet_8_1 = magnet_8.copy()
  magnet_9_1 = magnet_9.copy()
  rotor.subtract(magnet_1_1, magnet_10_1, magnet_11_1, magnet_12_1, magnet_13_1, magnet_14_1, magnet_15_1, magnet_16_1, magnet_17_1, magnet_18_1, magnet_19_1, magnet_2_1, magnet_20_1, magnet_3_1, magnet_4_1, magnet_5_1, magnet_6_1, magnet_7_1, magnet_8_1, magnet_9_1)
  Region [vacuum] = region(percentage_offset: +X=$paddingSize, -X=$paddingSize, +Y=$paddingSize, -Y=$paddingSize, +Z=2*$paddingSize, -Z=2*$paddingSize)
  motion_band [vacuum] = cylinder(axis=Z, base_centre=(0mm, 0mm, -$g/2), radius=$osd/2+10mm, height=$g+$dm+$dry+5mm) in RelativeCS1
  coordinate_system RelativeCS2 = origin=(0mm, 0mm, 0mm) x=(cos($alpha_s/2), sin($alpha_s/2), 0mm) y=(-sin($alpha_s/2), cos($alpha_s/2), 0mm)
  coilinput_1 [copper] = coil_1.section(plane=ZX) in RelativeCS2
  coilinput_1.separate_bodies()
  coilinput_2, coilinput_18, coilinput_3..coilinput_17 [copper] = coilinput_1.duplicate_around_axis(axis=Z, angle=360deg/18, total=18)
  Circle9 = circle(normal=Z, centre=(0mm, 0mm, -$g/2), radius=$isd/2) in RelativeCS1
  AG_surface = circle(normal=Z, centre=(0mm, 0mm, -$g/2), radius=$osd/2) in RelativeCS1
  AG_surface.subtract(Circle9)
  ccs_surface [vacuum, non-model] = circle(normal=Z, centre=(0mm, 0mm, -5mm), radius=$d/2)
  ccs_surface.sweep_along_vector((0mm, 0mm, $L_axial+10mm))
boundaries and excitations:
  coilinput_1: Coil Terminal Objects=coilinput_1 Conductor_number=$Ntc Winding=phaseA Point_out_of_terminal=true
  coilinput_2: Coil Terminal Objects=coilinput_2 Conductor_number=$Ntc Winding=phaseA Point_out_of_terminal=false
  coilinput_10: Coil Terminal Objects=coilinput_10 Conductor_number=$Ntc Winding=phaseA Point_out_of_terminal=true
  coilinput_11: Coil Terminal Objects=coilinput_11 Conductor_number=$Ntc Winding=phaseA Point_out_of_terminal=false
  coilinput_9: Coil Terminal Objects=coilinput_9 Conductor_number=$Ntc Winding=phaseA Point_out_of_terminal=false
  coilinput_18: Coil Terminal Objects=coilinput_18 Conductor_number=$Ntc Winding=phaseA Point_out_of_terminal=false
  coilinput_7: Coil Terminal Objects=coilinput_7 Conductor_number=$Ntc Winding=phaseB Point_out_of_terminal=true
  coilinput_16: Coil Terminal Objects=coilinput_16 Conductor_number=$Ntc Winding=phaseB Point_out_of_terminal=true
  coilinput_8: Coil Terminal Objects=coilinput_8 Conductor_number=$Ntc Winding=phaseB Point_out_of_terminal=false
  coilinput_17: Coil Terminal Objects=coilinput_17 Conductor_number=$Ntc Winding=phaseB Point_out_of_terminal=false
  coilinput_15: Coil Terminal Objects=coilinput_15 Conductor_number=$Ntc Winding=phaseB Point_out_of_terminal=false
  coilinput_6: Coil Terminal Objects=coilinput_6 Conductor_number=$Ntc Winding=phaseB Point_out_of_terminal=false
  coilinput_13: Coil Terminal Objects=coilinput_13 Conductor_number=$Ntc Winding=phaseC Point_out_of_terminal=true
  coilinput_4: Coil Terminal Objects=coilinput_4 Conductor_number=$Ntc Winding=phaseC Point_out_of_terminal=true
  coilinput_3: Coil Terminal Objects=coilinput_3 Conductor_number=$Ntc Winding=phaseC Point_out_of_terminal=false
  coilinput_5: Coil Terminal Objects=coilinput_5 Conductor_number=$Ntc Winding=phaseC Point_out_of_terminal=false
  coilinput_12: Coil Terminal Objects=coilinput_12 Conductor_number=$Ntc Winding=phaseC Point_out_of_terminal=false
  coilinput_14: Coil Terminal Objects=coilinput_14 Conductor_number=$Ntc Winding=phaseC Point_out_of_terminal=false
  phaseA: Winding Group Type=Current IsSolid=false Current=0mA ParallelBranchesNum=1
  phaseB: Winding Group Type=Current IsSolid=false Current=0mA ParallelBranchesNum=1
  phaseC: Winding Group Type=Current IsSolid=false Current=0mA ParallelBranchesNum=1
mesh:
  Length1: LengthBased RefineInside Objects=[coil_1..coil_18] MaxLength=$dc/3
  SurfApprox1: SurfApproxBased Faces=coil_1.face(at (102.42, 18.0594, 31.2641), at (44.3163, 7.81417, 31.2641), at (49.2404, 8.68241, 31.2641), at (76.7327, 6, 31.2641), at (107.344, 18.9277, 31.2641), at (78.1831, 1, 31.2641), at (45.6695, 1.66826, 31.2641), at (74.1573, 20.606, 31.2641), at (73.8101, 25.8005, 31.2641), at (43.4859, 14.0522, 31.2641)) coil_2.face(at (90.0666, 52, 31.2641), at (38.9711, 22.5, 31.2641), at (43.3013, 25, 31.2641), at (70.0531, 31.8823, 31.2641), at (94.3968, 54.5, 31.2641), at (73.1261, 27.6799, 31.2641), at (42.3447, 17.1875, 31.2641), at (62.6374, 44.7266, 31.2641), at (60.5346, 49.4891, 31.2641), at (36.0572, 28.0778, 31.2641)) coil_3.face(at (66.8499, 79.6686, 31.2641), at (28.9254, 34.472, 31.2641), at (32.1394, 38.3022, 31.2641), at (54.924, 53.9191, 31.2641), at (70.0638, 83.4988, 31.2641), at (59.249, 51.0212, 31.2641), at (33.9125, 30.6337, 31.2641), at (43.5625, 63.4525, 31.2641), at (39.9576, 67.2086, 31.2641), at (24.2795, 38.7168, 31.2641)) coil_4.face(at (35.5701, 97.728, 31.2641), at (15.3909, 42.2862, 31.2641), at (17.101, 46.9846, 31.2641), at (33.1702, 69.4525, 31.2641), at (37.2802, 102.426, 31.2641), at (38.2255, 68.2086, 31.2641), at (21.39, 40.3851, 31.2641), at (19.2333, 74.5251, 31.2641), at (14.5612, 76.8217, 31.2641), at (9.57334, 44.686, 31.2641)) coil_5.face(at (0, 104, 31.2641), at (0, 45, 31.2641), at (0, 50, 31.2641), at (7.41565, 76.6089, 31.2641), at (0, 109, 31.2641), at (12.5916, 77.169, 31.2641), at (6.28751, 45.2654, 31.2641), at (-7.41565, 76.6089, 31.2641), at (-12.5916, 77.169, 31.2641), at (-6.28751, 45.2654, 31.2641)) coil_6.face(at (-35.5701, 97.728, 31.2641), at (-15.3909, 42.2862, 31.2641), at (-17.101, 46.9846, 31.2641), at (-19.2333, 74.5251, 31.2641), at (-37.2802, 102.426, 31.2641), at (-14.5612, 76.8217, 31.2641), at (-9.57334, 44.686, 31.2641), at (-33.1702, 69.4525, 31.2641), at (-38.2255, 68.2086, 31.2641), at (-21.39, 40.3851, 31.2641)) coil_7.face(at (-66.8499, 79.6686, 31.2641), at (-28.9254, 34.472, 31.2641), at (-32.1394, 38.3022, 31.2641), at (-43.5625, 63.4525, 31.2641), at (-70.0638, 83.4988, 31.2641), at (-39.9576, 67.2086, 31.2641), at (-24.2795, 38.7168, 31.2641), at (-54.924, 53.9191, 31.2641), at (-59.249, 51.0212, 31.2641), at (-33.9125, 30.6337, 31.2641)) coil_8.face(at (-90.0666, 52, 31.2641), at (-38.9711, 22.5, 31.2641), at (-43.3013, 25, 31.2641), at (-62.6374, 44.7266, 31.2641), at (-94.3968, 54.5, 31.2641), at (-60.5346, 49.4891, 31.2641), at (-36.0572, 28.0778, 31.2641), at (-70.0531, 31.8823, 31.2641), at (-73.1261, 27.6799, 31.2641), at (-42.3447, 17.1875, 31.2641)) coil_9.face(at (-102.42, 18.0594, 31.2641), at (-44.3163, 7.81417, 31.2641), at (-49.2404, 8.68241, 31.2641), at (-74.1573, 20.606, 31.2641), at (-107.344, 18.9277, 31.2641), at (-73.8101, 25.8005, 31.2641), at (-43.4859, 14.0522, 31.2641), at (-76.7327, 6, 31.2641), at (-78.1831, 1, 31.2641), at (-45.6695, 1.66826, 31.2641)) coil_10.face(at (-102.42, -18.0594, 31.2641), at (-44.3163, -7.81417, 31.2641), at (-49.2404, -8.68241, 31.2641), at (-76.7327, -6, 31.2641), at (-107.344, -18.9277, 31.2641), at (-78.1831, -1, 31.2641), at (-45.6695, -1.66826, 31.2641), at (-74.1573, -20.606, 31.2641), at (-73.8101, -25.8005, 31.2641), at (-43.4859, -14.0522, 31.2641)) coil_11.face(at (-90.0666, -52, 31.2641), at (-38.9711, -22.5, 31.2641), at (-43.3013, -25, 31.2641), at (-70.0531, -31.8823, 31.2641), at (-94.3968, -54.5, 31.2641), at (-73.1261, -27.6799, 31.2641), at (-42.3447, -17.1875, 31.2641), at (-62.6374, -44.7266, 31.2641), at (-60.5346, -49.4891, 31.2641), at (-36.0572, -28.0778, 31.2641)) coil_12.face(at (-66.8499, -79.6686, 31.2641), at (-28.9254, -34.472, 31.2641), at (-32.1394, -38.3022, 31.2641), at (-54.924, -53.9191, 31.2641), at (-70.0638, -83.4988, 31.2641), at (-59.249, -51.0212, 31.2641), at (-33.9125, -30.6337, 31.2641), at (-43.5625, -63.4525, 31.2641), at (-39.9576, -67.2086, 31.2641), at (-24.2795, -38.7168, 31.2641)) coil_13.face(at (-35.5701, -97.728, 31.2641), at (-15.3909, -42.2862, 31.2641), at (-17.101, -46.9846, 31.2641), at (-33.1702, -69.4525, 31.2641), at (-37.2802, -102.426, 31.2641), at (-38.2255, -68.2086, 31.2641), at (-21.39, -40.3851, 31.2641), at (-19.2333, -74.5251, 31.2641), at (-14.5612, -76.8217, 31.2641), at (-9.57334, -44.686, 31.2641)) coil_14.face(at (0, -104, 31.2641), at (0, -45, 31.2641), at (0, -50, 31.2641), at (-7.41565, -76.6089, 31.2641), at (0, -109, 31.2641), at (-12.5916, -77.169, 31.2641), at (-6.28751, -45.2654, 31.2641), at (7.41565, -76.6089, 31.2641), at (12.5916, -77.169, 31.2641), at (6.28751, -45.2654, 31.2641)) coil_15.face(at (35.5701, -97.728, 31.2641), at (15.3909, -42.2862, 31.2641), at (17.101, -46.9846, 31.2641), at (19.2333, -74.5251, 31.2641), at (37.2802, -102.426, 31.2641), at (14.5612, -76.8217, 31.2641), at (9.57334, -44.686, 31.2641), at (33.1702, -69.4525, 31.2641), at (38.2255, -68.2086, 31.2641), at (21.39, -40.3851, 31.2641)) coil_16.face(at (66.8499, -79.6686, 31.2641), at (28.9254, -34.472, 31.2641), at (32.1394, -38.3022, 31.2641), at (43.5625, -63.4525, 31.2641), at (70.0638, -83.4988, 31.2641), at (39.9576, -67.2086, 31.2641), at (24.2795, -38.7168, 31.2641), at (54.924, -53.9191, 31.2641), at (59.249, -51.0212, 31.2641), at (33.9125, -30.6337, 31.2641)) coil_17.face(at (90.0666, -52, 31.2641), at (38.9711, -22.5, 31.2641), at (43.3013, -25, 31.2641), at (62.6374, -44.7266, 31.2641), at (94.3968, -54.5, 31.2641), at (60.5346, -49.4891, 31.2641), at (36.0572, -28.0778, 31.2641), at (70.0531, -31.8823, 31.2641), at (73.1261, -27.6799, 31.2641), at (42.3447, -17.1875, 31.2641)) coil_18.face(at (102.42, -18.0594, 31.2641), at (44.3163, -7.81417, 31.2641), at (49.2404, -8.68241, 31.2641), at (74.1573, -20.606, 31.2641), at (107.344, -18.9277, 31.2641), at (73.8101, -25.8005, 31.2641), at (43.4859, -14.0522, 31.2641), at (76.7327, -6, 31.2641), at (78.1831, -1, 31.2641), at (45.6695, -1.66826, 31.2641)) CurvedSurfaceApproxChoice=ManualSettings NormalDev=40deg
  Length2: LengthBased RefineInside Objects=[coil_1..coil_18] MaxLength=$lstk/5
  Length3: LengthBased Objects=AG_surface MaxLength=$lstk/10
  initial mesh: GlobalCurvilinear{Apply}
setups:
  Setup1: Magnetostatic MaximumPasses=2 MinimumPasses=2 MinimumConvergedPasses=1 PercentRefinement=30 PercentError=1 NonLinearResidual=0.001
field plots:
  B_Vector3: B over AG_surface.face(at (0, 0, 59.85)) on Setup1 : LastAdaptive

design magnetic_loading (Maxwell 2D, Magnetostatic, XY geometry, model units mm)
options: ModelDepth=1meter
geometry:
  Polyline1 = polyline(z=0mm, xy: ($wst/2, $dsy) ($wst/2 +$wss/2, $dsy) ($wst/2 +$wss/2, $dsy+$dss+5mm) ($wst/2 +$wss/2-$bs0/2, $dsy+$dss+5mm) ($wst/2 +$wss/2-$bs0/2, $dsy+$dss-$hs0) ($wst/2, $dsy+$dss-$hs1) ($wst/2, $dsy), closed, covered)
  stator [Cogent Power - M330-35A, B-H at 50Hz - 2d] = rectangle(corner=(0mm, 0mm, 0mm), x_size=pi*$ad, y_size=$dss+$dsy)
  Polyline1_1 = Polyline1.duplicate_mirror(point=($wst/2+$wss/2, 0mm, 0mm), normal=(1mm, 0mm, 0mm))
  Polyline1_1.unite(Polyline1)
  Polyline1_1.duplicate_along_line(step=($wst+$wss, 0mm, 0mm), total=18, attached)
  stator.subtract(Polyline1_1)
  scain_1 [copper] = rectangle(corner=($wst/2+$papert, $dsy+$papert, 0mm), x_size=$wcc, y_size=$dc)
  scaout_2 [copper] = scain_1.duplicate_mirror(point=($wst/2+$wss/2, 0mm, 0mm), normal=(1mm, 0mm, 0mm))
  scain2..scain18 [copper] = scain_1.duplicate_along_line(step=($wss+$wst, 0mm, 0mm), total=18)
  scaout3..scaout17, scaout_18, scaout_1 [copper] = scaout_2.duplicate_along_line(step=($wst+$wss, 0mm, 0mm), total=18)
  coordinate_system north_cs = origin=(0mm, 0mm, 0mm) x=(0mm, 75mm, 0mm) y=(-75mm, 0mm, 0mm)
  magnet_1 [Arnold - N38, oriented by north_cs] = rectangle(corner=($bm0/2, $dss+$dsy+$g, 0mm), x_size=$wm, y_size=$dm)
  magnet_2 [Arnold - N38, oriented by south_cs], magnet_3 [Arnold - N38, oriented by north_cs], magnet_4 [Arnold - N38, oriented by south_cs], magnet_5 [Arnold - N38, oriented by north_cs], magnet_6 [Arnold - N38, oriented by south_cs], magnet_7 [Arnold - N38, oriented by north_cs], magnet_8 [Arnold - N38, oriented by south_cs], magnet_9 [Arnold - N38, oriented by north_cs], magnet_10 [Arnold - N38, oriented by south_cs], magnet_11 [Arnold - N38, oriented by north_cs], magnet_12 [Arnold - N38, oriented by south_cs], magnet_13 [Arnold - N38, oriented by north_cs], magnet_14 [Arnold - N38, oriented by south_cs], magnet_15 [Arnold - N38, oriented by north_cs], magnet_16 [Arnold - N38, oriented by south_cs], magnet_17 [Arnold - N38, oriented by north_cs], magnet_18 [Arnold - N38, oriented by south_cs], magnet_19 [Arnold - N38, oriented by north_cs], magnet_20 [Arnold - N38, oriented by south_cs] = magnet_1.duplicate_along_line(step=($bm0+$wm, 0mm, 0mm), total=20)
  coordinate_system south_cs = origin=(0mm, 0mm, 0mm) x=(0mm, -40mm, 0mm) y=(40mm, 0mm, 0mm)
  rotor [steel_1010] = rectangle(corner=(0mm, $dsy+$dss+$g+$dm-$dm0, 0mm), x_size=pi*$ad, y_size=$dm0+$dry)
  magnet_1_20 = magnet_1.copy()
  magnet_1_1_1 = magnet_2.copy()
  magnet_1_10_1 = magnet_11.copy()
  magnet_1_11_1 = magnet_12.copy()
  magnet_1_12_1 = magnet_13.copy()
  magnet_1_13_1 = magnet_14.copy()
  magnet_1_14_1 = magnet_15.copy()
  magnet_1_15_1 = magnet_16.copy()
  magnet_1_16_1 = magnet_17.copy()
  magnet_1_17_1 = magnet_18.copy()
  magnet_1_18_1 = magnet_19.copy()
  magnet_1_19_1 = magnet_20.copy()
  magnet_1_2_1 = magnet_3.copy()
  magnet_1_3_1 = magnet_4.copy()
  magnet_1_4_1 = magnet_5.copy()
  magnet_1_5_1 = magnet_6.copy()
  magnet_1_6_1 = magnet_7.copy()
  magnet_1_7_1 = magnet_8.copy()
  magnet_1_8_1 = magnet_9.copy()
  magnet_1_9_1 = magnet_10.copy()
  rotor.subtract(magnet_1_20, magnet_1_1_1, magnet_1_10_1, magnet_1_11_1, magnet_1_12_1, magnet_1_13_1, magnet_1_14_1, magnet_1_15_1, magnet_1_16_1, magnet_1_17_1, magnet_1_18_1, magnet_1_19_1, magnet_1_2_1, magnet_1_3_1, magnet_1_4_1, magnet_1_5_1, magnet_1_6_1, magnet_1_7_1, magnet_1_8_1, magnet_1_9_1)
  region [vacuum] = rectangle(corner=(0mm, -10mm, 0mm), x_size=pi*$ad, y_size=$L_axial +20mm)
  Polyline2_bavg [non-model] = polyline((0mm, $dsy+$dss+$g/2, 0mm) (pi*$ad, $dsy+$dss+$g/2, 0mm))
boundaries and excitations:
  VectorPotential1: Vector Potential Edges=region.edge(at (241.903, 83.393, 0), at (241.903, -10, 0)) Value=0
  Independent1: Independent Edges=region.edge(at (0, 36.6965, 0)) ReverseV
  Dependent1: Dependent Edges=region.edge(at (483.805, 36.6965, 0)) Independent=Independent1 SameAsMaster=true
mesh:
  Length1: LengthBased RefineInside Objects=[magnet_1..magnet_20, stator, scain_1, scain2..scain18, scaout_1, scaout_2, scaout_18, scaout3..scaout17, rotor, region] MaxLength=3mm
setups:
  magnetic_loading: Magnetostatic MaximumPasses=10 MinimumPasses=2 MinimumConvergedPasses=1 PercentRefinement=30 PercentError=1 NonLinearResidual=0.0001
  magnetic_loading1: Magnetostatic MeshLink{ImportMesh LinkID=221 Project="This Project*" Design="This Design*" Params{$bm0=$bm0 $bs0=$bs0 $bw0=$bw0 $d=$d $dm=$dm $dm0=$dm0 $dry=$dry $dss=$dss $dsy=$dsy $g=$g $hs0=$hs0 $iph_rms=$iph_rms $isd=$isd $ns=$ns $ntc=$ntc $osd=$osd $p=$p $paddingSize=$paddingSize $papert=$papert $t=$t $tta=$tta $wss=$wss} PathRelativeTo=TargetProject} MaximumPasses=1 MinimumPasses=1 MinimumConvergedPasses=1 PercentRefinement=30 PercentError=1 NonLinearResidual=0.0001
field calculator expressions:
  by = Fundamental_Quantity(22) | ScalarY
field plots:
  Flux_Lines1: A on magnetic_loading : LastAdaptive
  Mag_B1, B_Vector1: B on magnetic_loading : LastAdaptive
reports:
  Calculator Expressions Plot1: by vs Distance on magnetic_loading : LastAdaptive
  Calculator Expressions Table1: by vs Distance on magnetic_loading : LastAdaptive

design steady_state_2d (Maxwell 2D, Transient, XY geometry, model units mm)
options: ModelDepth=1meter
variables:
  rotor_rpm = 750rpm
  linearspeed = ($d/2meter)*2*pi*(rotor_rpm/60rpm)*1m_per_sec
geometry:
  Polyline1 = polyline(z=0mm, xy: ($wst/2, $dsy) ($wst/2 +$wss/2, $dsy) ($wst/2 +$wss/2, $dsy+$dss+5mm) ($wst/2 +$wss/2-$bs0/2, $dsy+$dss+5mm) ($wst/2 +$wss/2-$bs0/2, $dsy+$dss-$hs0) ($wst/2, $dsy+$dss-$hs1) ($wst/2, $dsy), closed, covered)
  stator [Cogent Power - M330-35A, B-H at 50Hz - 2d] = rectangle(corner=(0mm, 0mm, 0mm), x_size=pi*$ad, y_size=$dss+$dsy)
  Polyline1_1 = Polyline1.duplicate_mirror(point=($wst/2+$wss/2, 0mm, 0mm), normal=(1mm, 0mm, 0mm))
  Polyline1_1.unite(Polyline1)
  Polyline1_1.duplicate_along_line(step=($wst+$wss, 0mm, 0mm), total=18, attached)
  stator.subtract(Polyline1_1)
  scain1 [copper] = rectangle(corner=($wst/2+$papert, $dsy+$papert, 0mm), x_size=$wcc, y_size=$dc)
  scaout2 [copper] = scain1.duplicate_mirror(point=($wst/2+$wss/2, 0mm, 0mm), normal=(1mm, 0mm, 0mm))
  scain2..scain18 [copper] = scain1.duplicate_along_line(step=($wss+$wst, 0mm, 0mm), total=18)
  scaout3..scaout18, scaout1 [copper] = scaout2.duplicate_along_line(step=($wst+$wss, 0mm, 0mm), total=18)
  coordinate_system north_cs = origin=(0mm, 0mm, 0mm) x=(0mm, 75mm, 0mm) y=(-75mm, 0mm, 0mm)
  magnet_1 [Arnold - N38, oriented by north_cs] = rectangle(corner=($bm0/2, $dss+$dsy+$g, 0mm), x_size=$wm, y_size=$dm)
  magnet_2 [Arnold - N38, oriented by south_cs], magnet_3 [Arnold - N38, oriented by north_cs], magnet_4 [Arnold - N38, oriented by south_cs], magnet_5 [Arnold - N38, oriented by north_cs], magnet_6 [Arnold - N38, oriented by south_cs], magnet_7 [Arnold - N38, oriented by north_cs], magnet_8 [Arnold - N38, oriented by south_cs], magnet_9 [Arnold - N38, oriented by north_cs], magnet_10 [Arnold - N38, oriented by south_cs], magnet_11 [Arnold - N38, oriented by north_cs], magnet_12 [Arnold - N38, oriented by south_cs], magnet_13 [Arnold - N38, oriented by north_cs], magnet_14 [Arnold - N38, oriented by south_cs], magnet_15 [Arnold - N38, oriented by north_cs], magnet_16 [Arnold - N38, oriented by south_cs], magnet_17 [Arnold - N38, oriented by north_cs], magnet_18 [Arnold - N38, oriented by south_cs], magnet_19 [Arnold - N38, oriented by north_cs], magnet_20 [Arnold - N38, oriented by south_cs] = magnet_1.duplicate_along_line(step=($bm0+$wm, 0mm, 0mm), total=20)
  coordinate_system south_cs = origin=(0mm, 0mm, 0mm) x=(0mm, -40mm, 0mm) y=(40mm, 0mm, 0mm)
  rotor [steel_1010] = rectangle(corner=(0mm, $dsy+$dss+$g+$dm-$dm0, 0mm), x_size=pi*$ad, y_size=$dm0+$dry)
  magnet_1_20 = magnet_1.copy()
  magnet_1_1_1 = magnet_2.copy()
  magnet_1_10_1 = magnet_11.copy()
  magnet_1_11_1 = magnet_12.copy()
  magnet_1_12_1 = magnet_13.copy()
  magnet_1_13_1 = magnet_14.copy()
  magnet_1_14_1 = magnet_15.copy()
  magnet_1_15_1 = magnet_16.copy()
  magnet_1_16_1 = magnet_17.copy()
  magnet_1_17_1 = magnet_18.copy()
  magnet_1_18_1 = magnet_19.copy()
  magnet_1_19_1 = magnet_20.copy()
  magnet_1_2_1 = magnet_3.copy()
  magnet_1_3_1 = magnet_4.copy()
  magnet_1_4_1 = magnet_5.copy()
  magnet_1_5_1 = magnet_6.copy()
  magnet_1_6_1 = magnet_7.copy()
  magnet_1_7_1 = magnet_8.copy()
  magnet_1_8_1 = magnet_9.copy()
  magnet_1_9_1 = magnet_10.copy()
  rotor.subtract(magnet_1_20, magnet_1_1_1, magnet_1_10_1, magnet_1_11_1, magnet_1_12_1, magnet_1_13_1, magnet_1_14_1, magnet_1_15_1, magnet_1_16_1, magnet_1_17_1, magnet_1_18_1, magnet_1_19_1, magnet_1_2_1, magnet_1_3_1, magnet_1_4_1, magnet_1_5_1, magnet_1_6_1, magnet_1_7_1, magnet_1_8_1, magnet_1_9_1)
  region [vacuum] = rectangle(corner=(0mm, -10mm, 0mm), x_size=pi*$ad, y_size=$L_axial +20mm)
  Polyline2_bavg [non-model] = polyline((0mm, $dsy+$dss+$g/2, 0mm) (pi*$ad, $dsy+$dss+$g/2, 0mm))
  motion_band [vacuum] = rectangle(corner=(0mm, $dsy+$dss+$g/2, 0mm), x_size=pi*$d, y_size=$g+$dm+$dry+5mm)
motion:
  MotionSetup1: Band Move_Type=Translate Coordinate_System=Global PostProcessing_Coordinate_System=Global Axis=X Is_Positive=true InitPos=0mm TranslatePeriodic Velocity=linearspeed Objects=motion_band
  Moving1: Moving Objects=[magnet_1..magnet_20, rotor]
boundaries and excitations:
  VectorPotential1: Vector Potential Edges=region.edge(at (241.903, 83.393, 0), at (241.903, -10, 0)) Value=0
  Independent1: Independent Edges=region.edge(at (0, 36.6965, 0)) ReverseV
  Dependent1: Dependent Edges=region.edge(at (483.805, 36.6965, 0)) Independent=Independent1 SameAsMaster=true
  scain1: Coil Objects=scain1 Conductor_number=$Ntc Winding=phaseA PolarityType=Positive
  scaout1: Coil Objects=scaout1 Conductor_number=$Ntc Winding=phaseA PolarityType=Negative
  scain7: Coil Objects=scain7 Conductor_number=$Ntc Winding=phaseB PolarityType=Positive
  scaout7: Coil Objects=scaout7 Conductor_number=$Ntc Winding=phaseB PolarityType=Negative
  scain13: Coil Objects=scain13 Conductor_number=$Ntc Winding=phaseC PolarityType=Positive
  scaout13: Coil Objects=scaout13 Conductor_number=$Ntc Winding=phaseC PolarityType=Negative
  scain10: Coil Objects=scain10 Conductor_number=$Ntc Winding=phaseA PolarityType=Positive
  scaout10: Coil Objects=scaout10 Conductor_number=$Ntc Winding=phaseA PolarityType=Negative
  scain16: Coil Objects=scain16 Conductor_number=$Ntc Winding=phaseB PolarityType=Positive
  scaout16: Coil Objects=scaout16 Conductor_number=$Ntc Winding=phaseB PolarityType=Negative
  scain4: Coil Objects=scain4 Conductor_number=$Ntc Winding=phaseC PolarityType=Positive
  scaout4: Coil Objects=scaout4 Conductor_number=$Ntc Winding=phaseC PolarityType=Negative
  scain2: Coil Objects=scain2 Conductor_number=$Ntc Winding=phaseA PolarityType=Negative
  scaout2: Coil Objects=scaout2 Conductor_number=$Ntc Winding=phaseA PolarityType=Positive
  scain8: Coil Objects=scain8 Conductor_number=$Ntc Winding=phaseB PolarityType=Negative
  scaout8: Coil Objects=scaout8 Conductor_number=$Ntc Winding=phaseB PolarityType=Positive
  scain14: Coil Objects=scain14 Conductor_number=$Ntc Winding=phaseC PolarityType=Negative
  scaout14: Coil Objects=scaout14 Conductor_number=$Ntc Winding=phaseC PolarityType=Positive
  scain11: Coil Objects=scain11 Conductor_number=$Ntc Winding=phaseA PolarityType=Negative
  scaout11: Coil Objects=scaout11 Conductor_number=$Ntc Winding=phaseA PolarityType=Positive
  scain17: Coil Objects=scain17 Conductor_number=$Ntc Winding=phaseB PolarityType=Negative
  scaout17: Coil Objects=scaout17 Conductor_number=$Ntc Winding=phaseB PolarityType=Positive
  scain5: Coil Objects=scain5 Conductor_number=$Ntc Winding=phaseC PolarityType=Negative
  scaout5: Coil Objects=scaout5 Conductor_number=$Ntc Winding=phaseC PolarityType=Positive
  scain9: Coil Objects=scain9 Conductor_number=$Ntc Winding=phaseA PolarityType=Negative
  scaout9: Coil Objects=scaout9 Conductor_number=$Ntc Winding=phaseA PolarityType=Positive
  scain15: Coil Objects=scain15 Conductor_number=$Ntc Winding=phaseB PolarityType=Negative
  scaout15: Coil Objects=scaout15 Conductor_number=$Ntc Winding=phaseB PolarityType=Positive
  scain3: Coil Objects=scain3 Conductor_number=$Ntc Winding=phaseC PolarityType=Negative
  scaout3: Coil Objects=scaout3 Conductor_number=$Ntc Winding=phaseC PolarityType=Positive
  scain18: Coil Objects=scain18 Conductor_number=$Ntc Winding=phaseA PolarityType=Negative
  scaout18: Coil Objects=scaout18 Conductor_number=$Ntc Winding=phaseA PolarityType=Positive
  scain6: Coil Objects=scain6 Conductor_number=$Ntc Winding=phaseB PolarityType=Negative
  scaout6: Coil Objects=scaout6 Conductor_number=$Ntc Winding=phaseB PolarityType=Positive
  scain12: Coil Objects=scain12 Conductor_number=$Ntc Winding=phaseC PolarityType=Negative
  scaout12: Coil Objects=scaout12 Conductor_number=$Ntc Winding=phaseC PolarityType=Positive
  phaseA: Winding Group Type=Current IsSolid=false Current=0mA ParallelBranchesNum=1
  phaseB: Winding Group Type=Current IsSolid=false Current=0mA ParallelBranchesNum=1
  phaseC: Winding Group Type=Current IsSolid=false Current=0mA ParallelBranchesNum=1
mesh:
  Length1: LengthBased RefineInside Objects=[magnet_1..magnet_20, stator, scain1..scain18, scaout1, scaout2, scaout18, scaout3..scaout17, rotor, region] MaxLength=3mm
setups:
  Setup1: Transient NonlinearSolverResidual=0.0001 StopTime=8ms TimeStep=8ms/50 SaveFieldsType="Every N Steps" N_Steps=1 Steps_From=0s Steps_To=8ms NumberSolveSteps=1 RangeStart=0s RangeEnd=0.1s InitialTimeStep=0.002s MinTimeStep=0.001s MaxTimeStep=0.003s TimeStepErrTolerance=0.0001
  Setup2: Transient MeshLink{ImportMesh LinkID=606 Project="This Project*" Design="This Design*" Params{$bm0=$bm0 $bs0=$bs0 $bw0=$bw0 $d=$d $dm=$dm $dm0=$dm0 $dry=$dry $dss=$dss $dsy=$dsy $g=$g $hs0=$hs0 $iph_rms=$iph_rms $isd=$isd $ns=$ns $ntc=$ntc $osd=$osd $p=$p $paddingSize=$paddingSize $papert=$papert $t=$t $tta=$tta $wss=$wss rotor_rpm=rotor_rpm} PathRelativeTo=TargetProject} NonlinearSolverResidual=0.0001 StopTime=8ms TimeStep=8ms/50 SaveFieldsType="Every N Steps" N_Steps=1 Steps_From=0s Steps_To=8ms NumberSolveSteps=1 RangeStart=0s RangeEnd=0.1s InitialTimeStep=0.002s MinTimeStep=0.001s MaxTimeStep=0.003s TimeStepErrTolerance=0.0001
output variables:
  te = ($d/2)*Moving1.Force_x
field plots:
  Flux_Lines1: A on Setup1 : Transient at Time=0s
reports:
  Winding Plot2: InducedVoltage(phaseA), InducedVoltage(phaseB), InducedVoltage(phaseC) vs Time on Setup1 : Transient
  Output Variables Plot1: te vs Time on Setup1 : Transient
  Winding Plot3: FluxLinkage(phaseA), FluxLinkage(phaseB), FluxLinkage(phaseC) vs Time on Setup1 : Transient [$ntc=all]
