# Ansys Electronics Desktop project, version 2025.1
project variables:
  $di = 75mm
  $d0 = 120mm
  $slots = 24
  $hso = 0.5mm
  $hs1 = 1mm
  $hs2 = 8.2mm
  $bs0 = 2.5mm
  $bs1 = 5.6mm
  $bs2 = 7.6mm
  $rs = 3.8mm
  $dro = 74mm
  $dri = 26mm
  $P = 4
  $ep = 0.8
  $tm = 3.5mm
  $wm = 3.5mm
  $rib = 0.7mm
  $tc = 25
  $vph = 230V
  $R = 2ohm
  $alignment = 0deg
  $ns = 0rad_per_sec
  $J = 0
  $B = 0
  $MN = -5NewtonMeter
  $inertia = 0.00149257kgm2
  $iph = 2A
materials:
  vacuum: permittivity=1
  copper: permeability=0.999991 conductivity=58000000
  Cogent Power - M250-35A, B-H at 50Hz: core_loss_curve{50Hz (0, 0) (0.05, 0.01) (0.1, 0.02) (0.15, 0.04) (0.2, 0.06) (0.25, 0.095) (0.3, 0.13) (0.35, 0.17) (0.4, 0.21) (0.45, 0.26) (0.5, 0.31) (0.55, 0.36) (0.6, 0.41) (0.65, 0.465) (0.7, 0.52) (0.75, 0.59) (0.8, 0.66) (0.85, 0.735) (0.9, 0.81) (0.95, 0.895) (1, 0.98) (1.05, 1.065) (1.1, 1.15) (1.15, 1.26) (1.2, 1.37) (1.25, 1.51) (1.3, 1.65) (1.35, 1.825) (1.4, 2) (1.45, 2.175) (1.5, 2.35) (1.55, 2.5) (1.6, 2.65) (1.65, 2.76) (1.7, 2.87) (1.75, 2.965) (1.8, 3.06)} core_loss_curve{100Hz (0, 0) (0.05, 0.02) (0.1, 0.04) (0.15, 0.09) (0.2, 0.14) (0.25, 0.225) (0.3, 0.31) (0.35, 0.41) (0.4, 0.51) (0.45, 0.63) (0.5, 0.75) (0.55, 0.88) (0.6, 1.01) (0.65, 1.16) (0.7, 1.31) (0.75, 1.475) (0.8, 1.64) (0.85, 1.82) (0.9, 2) (0.95, 2.205) (1, 2.41) (1.05, 2.64) (1.1, 2.87) (1.15, 3.135) (1.2, 3.4) (1.25, 3.715) (1.3, 4.03) (1.35, 4.43) (1.4, 4.83) (1.45, 5.275) (1.5, 5.72) (1.55, 6.165) (1.6, 6.61) (1.65, 7.055) (1.7, 7.5) (1.75, 7.945) (1.8, 8.39)} core_loss_curve{200Hz (0, 0) (0.05, 0.04) (0.1, 0.08) (0.15, 0.205) (0.2, 0.33) (0.25, 0.53) (0.3, 0.73) (0.35, 0.98) (0.4, 1.23) (0.45, 1.525) (0.5, 1.82) (0.55, 2.155) (0.6, 2.49) (0.65, 2.875) (0.7, 3.26) (0.75, 3.69) (0.8, 4.12) (0.85, 4.595) (0.9, 5.07) (0.95, 5.605) (1, 6.14) (1.05, 6.735) (1.1, 7.33) (1.15, 8.01) (1.2, 8.69) (1.25, 9.495) (1.3, 10.3) (1.35, 11.35) (1.4, 12.4) (1.45, 13.55) (1.5, 14.7) (1.55, 15.85) (1.6, 17) (1.65, 18.15) (1.7, 19.3) (1.75, 20.45) (1.8, 21.6)} core_loss_curve{400Hz (0, 0) (0.05, 0.105) (0.1, 0.21) (0.15, 0.555) (0.2, 0.9) (0.25, 1.415) (0.3, 1.93) (0.35, 2.585) (0.4, 3.24) (0.45, 4.025) (0.5, 4.81) (0.55, 5.75) (0.6, 6.69) (0.65, 7.755) (0.7, 8.82) (0.75, 10.01) (0.8, 11.2) (0.85, 12.6) (0.9, 14) (0.95, 15.55) (1, 17.1) (1.05, 18.85) (1.1, 20.6) (1.15, 22.6) (1.2, 24.6) (1.25, 26.9) (1.3, 29.2) (1.35, 32.15) (1.4, 35.1) (1.45, 38.35) (1.5, 41.6) (1.55, 44.85) (1.6, 48.1) (1.65, 51.35) (1.7, 54.6) (1.75, 57.85) (1.8, 61.1)} core_loss_curve{1000Hz (0, 0) (0.05, 0.49) (0.1, 0.98) (0.15, 2.315) (0.2, 3.65) (0.25, 5.615) (0.3, 7.58) (0.35, 10.14) (0.4, 12.7) (0.45, 15.75) (0.5, 18.8) (0.55, 22.55) (0.6, 26.3) (0.65, 30.75) (0.7, 35.2) (0.75, 40.45) (0.8, 45.7) (0.85, 51.9) (0.9, 58.1) (0.95, 65.35) (1, 72.6) (1.05, 81.1) (1.1, 89.6) (1.15, 98.1) (1.2, 106.6) (1.25, 115.1) (1.3, 123.6) (1.35, 132.1) (1.4, 140.6) (1.45, 149.1) (1.5, 157.6) (1.55, 166.1) (1.6, 174.6) (1.65, 183.1) (1.7, 191.6) (1.75, 200.1) (1.8, 208.6)} permeability{HUnit=A_per_meter BUnit=tesla curve (0, 0) (5, 0.00973865) (10, 0.0213622) (15, 0.037698) (20, 0.0578036) (26.8, 0.1) (35.7, 0.2) (41.8, 0.3) (47.5, 0.4) (53.4, 0.5) (60, 0.6) (67.9, 0.7) (77.5, 0.8) (90, 0.9) (107, 1) (133, 1.1) (179, 1.2) (284, 1.3) (642, 1.4) (1810, 1.5) (4030, 1.6) (7290, 1.7) (11700, 1.8) (23345, 1.9396) (46579, 2.0315) (92937, 2.1211) (185430, 2.2531) (369980, 2.4929) (738210, 2.9596)} conductivity=1818180 core_loss_type="Power Ferrite" core_loss_cm=32.3209 core_loss_x=1.78587 core_loss_y=1.39979 mass_density=7650 stacking_type=Lamination stacking_factor=0.95 stacking_direction=V(3)
  Arnold_Magnetics_N42EH_100C: permeability{HUnit=A_per_meter BUnit=tesla curve (-1526000, -1.9844) (-1523000, -1.4535) (-1512000, -1.0379) (-1490000, -0.8648) (-1472000, -0.8059) (-1454000, -0.7638) (-1436000, -0.729) (-1418000, -0.6978) (-1400000, -0.6688) (-1382000, -0.6412) (-1364000, -0.6145) (-1346000, -0.5885) (-1328000, -0.5629) (-1310000, -0.5378) (-1292000, -0.5128) (-1274000, -0.4881) (-1256000, -0.4636) (-1239000, -0.4393) (-1221000, -0.415) (-1203000, -0.3909) (-1185000, -0.3668) (-1167000, -0.3428) (-1149000, -0.3189) (-1131000, -0.295) (-1113000, -0.2711) (-1095000, -0.2473) (-1077000, -0.2236) (-1059000, -0.1999) (-1041000, -0.1762) (-1023000, -0.1525) (-1005000, -0.1288) (-987000, -0.1052) (-969000, -0.0816) (-951000, -0.058) (-933000, -0.0344) (-915000, -0.0108) (-897000, 0.0127) (-880000, 0.0363) (-862000, 0.0598) (-844000, 0.0833) (-826000, 0.1068) (-808000, 0.1304) (-790000, 0.1538) (-772000, 0.1773) (-754000, 0.2008) (-736000, 0.2243) (-718000, 0.2478) (-700000, 0.2712) (-682000, 0.2947) (-664000, 0.3182) (-646000, 0.3416) (-628000, 0.3651) (-610000, 0.3885) (-592000, 0.4119) (-574000, 0.4354) (-556000, 0.4588) (-538000, 0.4822) (-521000, 0.5057) (-503000, 0.5291) (-485000, 0.5525) (-467000, 0.5759) (-449000, 0.5994) (-431000, 0.6228) (-413000, 0.6462) (-395000, 0.6696) (-377000, 0.693) (-359000, 0.7164) (-341000, 0.7398) (-323000, 0.7632) (-305000, 0.7866) (-287000, 0.81) (-269000, 0.8334) (-251000, 0.8568) (-233000, 0.8802) (-215000, 0.9036) (-197000, 0.927) (-179000, 0.9504) (-162000, 0.9738) (-144000, 0.9972) (-126000, 1.0206) (-108000, 1.0439) (-90000, 1.0673) (-72000, 1.0907) (-54000, 1.1141) (-36000, 1.1375) (-18000, 1.1609) (0, 1.1842)} conductivity=555555.5556 magnetic_coercivity{Magnitude=-1022100A_per_meter DirComp1=1 DirComp2=0 DirComp3=0}
  Arnold_Magnetics_N42EH_100C - Copy: permeability{HUnit=A_per_meter BUnit=tesla curve (-1526000, -1.9844) (-1523000, -1.4535) (-1512000, -1.0379) (-1490000, -0.8648) (-1472000, -0.8059) (-1454000, -0.7638) (-1436000, -0.729) (-1418000, -0.6978) (-1400000, -0.6688) (-1382000, -0.6412) (-1364000, -0.6145) (-1346000, -0.5885) (-1328000, -0.5629) (-1310000, -0.5378) (-1292000, -0.5128) (-1274000, -0.4881) (-1256000, -0.4636) (-1239000, -0.4393) (-1221000, -0.415) (-1203000, -0.3909) (-1185000, -0.3668) (-1167000, -0.3428) (-1149000, -0.3189) (-1131000, -0.295) (-1113000, -0.2711) (-1095000, -0.2473) (-1077000, -0.2236) (-1059000, -0.1999) (-1041000, -0.1762) (-1023000, -0.1525) (-1005000, -0.1288) (-987000, -0.1052) (-969000, -0.0816) (-951000, -0.058) (-933000, -0.0344) (-915000, -0.0108) (-897000, 0.0127) (-880000, 0.0363) (-862000, 0.0598) (-844000, 0.0833) (-826000, 0.1068) (-808000, 0.1304) (-790000, 0.1538) (-772000, 0.1773) (-754000, 0.2008) (-736000, 0.2243) (-718000, 0.2478) (-700000, 0.2712) (-682000, 0.2947) (-664000, 0.3182) (-646000, 0.3416) (-628000, 0.3651) (-610000, 0.3885) (-592000, 0.4119) (-574000, 0.4354) (-556000, 0.4588) (-538000, 0.4822) (-521000, 0.5057) (-503000, 0.5291) (-485000, 0.5525) (-467000, 0.5759) (-449000, 0.5994) (-431000, 0.6228) (-413000, 0.6462) (-395000, 0.6696) (-377000, 0.693) (-359000, 0.7164) (-341000, 0.7398) (-323000, 0.7632) (-305000, 0.7866) (-287000, 0.81) (-269000, 0.8334) (-251000, 0.8568) (-233000, 0.8802) (-215000, 0.9036) (-197000, 0.927) (-179000, 0.9504) (-162000, 0.9738) (-144000, 0.9972) (-126000, 1.0206) (-108000, 1.0439) (-90000, 1.0673) (-72000, 1.0907) (-54000, 1.1141) (-36000, 1.1375) (-18000, 1.1609) (0, 1.1842)} conductivity=555555.5556 magnetic_coercivity{Magnitude=-1022100A_per_meter DirComp1=-1 DirComp2=0 DirComp3=0}

design CURRENTS (Maxwell 2D, Transient, XY geometry, model units mm)
options: ComputeTransientInductance ModelDepth=L
variables:
  L = 50mm
geometry:
  stator [Cogent Power - M250-35A, B-H at 50Hz] = user_primitive(RMxprt/SlotCore.dll, DiaGap=$di, DiaYoke=$d0, Length=0mm, Skew=0deg, Slots=$slots, SlotType=2, Hs0=$hso, Hs01=0mm, Hs1=$hs1, Hs2=$hs2, Bs0=$bs0, Bs1=$bs1, Bs2=$bs2, Rs=$rs, FilletType=0, HalfSlot=0, SegAngle=15deg, LenRegion=0mm, InfoCore=0)
  rotor [Cogent Power - M250-35A, B-H at 50Hz] = user_primitive(RMxprt/PMCore.dll, DiaGap=$dro, DiaYoke=$dri, Length=0mm, Poles=$P, PoleType=1, Embrace=$ep, ThickMag=$tm, WidthMag=$wm, Offset=0mm, Bridge=0mm, Rib=$rib, LenRegion=0mm, InfoCore=0)
  magents [vacuum, oriented by FaceCS1] = user_primitive(RMxprt/PMCore.dll, DiaGap=$dro, DiaYoke=$dri, Length=0mm, Poles=$P, PoleType=1, Embrace=$ep, ThickMag=$tm, WidthMag=$wm, Offset=0mm, Bridge=0mm, Rib=$rib, LenRegion=0mm, InfoCore=2)
  coordinate_system FaceCS1 = face of magents: Origin=(23.688077, 23.688077, 0) FaceID=magents.face(at (22.6635, 22.6635, 0)) AxisPosn=(26.162951, 26.162951, 0) WhichAxis=X ZRotationAngle=0deg XOffset=0mm YOffset=0mm FaceNormal(0, 0, 1)
  magents_1 [vacuum, oriented by FaceCS2] = magents.duplicate_around_axis(axis=Z, angle=2*pi/$P, total=2)
  coordinate_system FaceCS2 = face of magents_1: Origin=(-23.688077, 23.688077, 0) FaceID=magents_1.face(1 of 1) AxisPosn=(-26.162951, 26.162951, 0) WhichAxis=X ZRotationAngle=0deg XOffset=0mm YOffset=0mm FaceNormal(0, 0, 1)
  magents_2 [vacuum, oriented by FaceCS3] = magents.duplicate_around_axis(axis=Z, angle=2*2*pi/$P, total=2)
  coordinate_system FaceCS3 = face of magents_2: Origin=(-23.688077, -23.688077, 0) FaceID=magents_2.face(1 of 1) AxisPosn=(-26.162951, -26.162951, 0) WhichAxis=X ZRotationAngle=0deg XOffset=0mm YOffset=0mm FaceNormal(0, 0, 1)
  magents_1_1 [vacuum, oriented by FaceCS4] = magents_1.duplicate_around_axis(axis=Z, angle=2*2*pi/$P, total=2)
  coordinate_system FaceCS4 = face of magents_1_1: Origin=(23.688077, -23.688077, 0) FaceID=magents_1_1.face(1 of 1) AxisPosn=(26.162951, -26.162951, 0) WhichAxis=X ZRotationAngle=0deg XOffset=0mm YOffset=0mm FaceNormal(0, 0, 1)
  R_10 [copper] = user_primitive(RMxprt/LapCoil.dll, DiaGap=$di, DiaYoke=$d0, Length=0mm, Skew=0deg, Slots=$slots, SlotType=2, Hs0=$hso, Hs1=$hs1, Hs2=$hs2, Bs0=$bs0, Bs1=$bs1, Bs2=$bs2, Rs=$rs, FilletType=0, Layers=2, CoilPitch=6, EndExt=0mm, SpanExt=0mm, BendAngle=0deg, SegAngle=0deg, LenRegion=0mm, InfoCoil=0)
  R_7, Y_1, Y_5, Y_8, Y_6, B_12, B_13, B, B_14, R, R_12, R_14, R_5, Y_15, Y_7, Y_10, Y_9, B_11, B_7, B_9, B_6, R_11, R_8, R_6, R_13, Y_13, Y_2, Y_4, Y_12, B_1, B_8, B_10, B_15, R_3, R_1, R_4, R_9, Y_3, Y_14, Y_11, Y, B_2..B_5, R_2, R_15 [copper] = R_10.separate_bodies()
  region [vacuum] = circle(normal=Z, centre=(0mm, 0mm, 0mm), radius=61.554854mm)
  band [vacuum] = polyline((0mm, 0mm, 0mm) (37.15mm, 0mm, 0mm))
  band.sweep_around_axis(axis=Z, angle=360deg)
motion:
  MotionSetup1: Band Move_Type=Rotate Coordinate_System=Global Axis=Z Is_Positive=true InitPos=$alignment Angular_Velocity=1500rpm Moment_of_Inertia=$inertia Damping=0 Load_Torque=$MN Objects=band
  Moving1: Moving Objects=[rotor, magents, magents_1, magents_2, magents_1_1]
boundaries and excitations:
  VectorPotential1: Vector Potential Edges=region.edge(at (-61.5549, 0, 0)) Value=0
  R_2: Coil Objects=R_2 Conductor_number=$tc Winding=PhaseA PolarityType=Positive
  R_1: Coil Objects=R_1 Conductor_number=$tc Winding=PhaseA PolarityType=Positive
  R_10: Coil Objects=R_10 Conductor_number=$tc Winding=PhaseA PolarityType=Positive
  R_9: Coil Objects=R_9 Conductor_number=$tc Winding=PhaseA PolarityType=Positive
  R_11: Coil Objects=R_11 Conductor_number=$tc Winding=PhaseA PolarityType=Positive
  R_12: Coil Objects=R_12 Conductor_number=$tc Winding=PhaseA PolarityType=Positive
  R_5: Coil Objects=R_5 Conductor_number=$tc Winding=PhaseA PolarityType=Positive
  R_6: Coil Objects=R_6 Conductor_number=$tc Winding=PhaseA PolarityType=Positive
  R_14: Coil Objects=R_14 Conductor_number=$tc Winding=PhaseA PolarityType=Negative
  R_7: Coil Objects=R_7 Conductor_number=$tc Winding=PhaseA PolarityType=Negative
  R_15: Coil Objects=R_15 Conductor_number=$tc Winding=PhaseA PolarityType=Negative
  R: Coil Objects=R Conductor_number=$tc Winding=PhaseA PolarityType=Negative
  R_3: Coil Objects=R_3 Conductor_number=$tc Winding=PhaseA PolarityType=Negative
  R_8: Coil Objects=R_8 Conductor_number=$tc Winding=PhaseA PolarityType=Negative
  R_4: Coil Objects=R_4 Conductor_number=$tc Winding=PhaseA PolarityType=Negative
  R_13: Coil Objects=R_13 Conductor_number=$tc Winding=PhaseA PolarityType=Negative
  B_12: Coil Objects=B_12 Conductor_number=$tc Winding=phaseB PolarityType=Positive
  B_3: Coil Objects=B_3 Conductor_number=$tc Winding=phaseB PolarityType=Positive
  B_5: Coil Objects=B_5 Conductor_number=$tc Winding=phaseB PolarityType=Positive
  B: Coil Objects=B Conductor_number=$tc Winding=phaseB PolarityType=Positive
  B_1: Coil Objects=B_1 Conductor_number=$tc Winding=phaseB PolarityType=Positive
  B_7: Coil Objects=B_7 Conductor_number=$tc Winding=phaseB PolarityType=Positive
  B_10: Coil Objects=B_10 Conductor_number=$tc Winding=phaseB PolarityType=Positive
  B_6: Coil Objects=B_6 Conductor_number=$tc Winding=phaseB PolarityType=Positive
  B_11: Coil Objects=B_11 Conductor_number=$tc Winding=phaseB PolarityType=Negative
  B_13: Coil Objects=B_13 Conductor_number=$tc Winding=phaseB PolarityType=Negative
  B_14: Coil Objects=B_14 Conductor_number=$tc Winding=phaseB PolarityType=Negative
  B_9: Coil Objects=B_9 Conductor_number=$tc Winding=phaseB PolarityType=Negative
  B_4: Coil Objects=B_4 Conductor_number=$tc Winding=phaseB PolarityType=Negative
  B_15: Coil Objects=B_15 Conductor_number=$tc Winding=phaseB PolarityType=Negative
  B_2: Coil Objects=B_2 Conductor_number=$tc Winding=phaseB PolarityType=Negative
  B_8: Coil Objects=B_8 Conductor_number=$tc Winding=phaseB PolarityType=Negative
  Y_1: Coil Objects=Y_1 Conductor_number=$tc Winding=phaseC PolarityType=Negative
  Y_14: Coil Objects=Y_14 Conductor_number=$tc Winding=phaseC PolarityType=Negative
  Y_8: Coil Objects=Y_8 Conductor_number=$tc Winding=phaseC PolarityType=Negative
  Y: Coil Objects=Y Conductor_number=$tc Winding=phaseC PolarityType=Negative
  Y_7: Coil Objects=Y_7 Conductor_number=$tc Winding=phaseC PolarityType=Negative
  Y_13: Coil Objects=Y_13 Conductor_number=$tc Winding=phaseC PolarityType=Negative
  Y_4: Coil Objects=Y_4 Conductor_number=$tc Winding=phaseC PolarityType=Negative
  Y_9: Coil Objects=Y_9 Conductor_number=$tc Winding=phaseC PolarityType=Negative
  Y_15: Coil Objects=Y_15 Conductor_number=$tc Winding=phaseC PolarityType=Positive
  Y_5: Coil Objects=Y_5 Conductor_number=$tc Winding=phaseC PolarityType=Positive
  Y_6: Coil Objects=Y_6 Conductor_number=$tc Winding=phaseC PolarityType=Positive
  Y_10: Coil Objects=Y_10 Conductor_number=$tc Winding=phaseC PolarityType=Positive
  Y_3: Coil Objects=Y_3 Conductor_number=$tc Winding=phaseC PolarityType=Positive
  Y_2: Coil Objects=Y_2 Conductor_number=$tc Winding=phaseC PolarityType=Positive
  Y_11: Coil Objects=Y_11 Conductor_number=$tc Winding=phaseC PolarityType=Positive
  Y_12: Coil Objects=Y_12 Conductor_number=$tc Winding=phaseC PolarityType=Positive
  PhaseA: Winding Group Type=Current IsSolid=false Current=1.414*$iph*sin(2*pi*50*time) ParallelBranchesNum=1
  phaseB: Winding Group Type=Current IsSolid=false Current=1.414*$iph*sin(2*pi*50*time-2*pi/3) ParallelBranchesNum=1
  phaseC: Winding Group Type=Current IsSolid=false Current=1.414*$iph*sin(2*pi*50*time-4*pi/3) ParallelBranchesNum=1
mesh:
  CylindricalGap1: CylindricalGap Objects=band Objects=band
setups:
  Setup1: Transient NonlinearSolverResidual=0.0001 StopTime=0.2s TimeStep="(0.02/50) s" SaveFieldsType="Every N Steps" N_Steps=1 Steps_From=100ms Steps_To=400ms NumberSolveSteps=1 RangeStart=0s RangeEnd=0.1s InitialTimeStep=0.002s MinTimeStep=0.001s MaxTimeStep=0.003s TimeStepErrTolerance=0.0001
field plots:
  Flux_Lines1: A over stator, rotor, magents, magents_1, magents_2, magents_1_1, R_10, R_7, Y_1, Y_5, Y_8, Y_6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 on Setup1 : Transient at Time=40000000ns
reports:
  Torque Plot1: Moving1.Torque vs Time on Setup1 : Transient
  Speed Plot1: Moving1.Speed vs Time on Setup1 : Transient
  Position Plot1: Moving1.Position vs Time on Setup1 : Transient
  Winding Plot1: FluxLinkage(PhaseA), FluxLinkage(phaseB), FluxLinkage(phaseC) vs Time on Setup1 : Transient
  Winding Plot2: InducedVoltage(PhaseA), InducedVoltage(phaseB), InducedVoltage(phaseC) vs Time on Setup1 : Transient
  Winding Plot3: InputCurrent(PhaseA) vs Time on Setup1 : Transient

design VOLTAGE (Maxwell 2D, Transient, XY geometry, model units mm)
options: ComputeTransientInductance ModelDepth=1meter
geometry:
  stator [Cogent Power - M250-35A, B-H at 50Hz] = user_primitive(RMxprt/SlotCore.dll, DiaGap=$di, DiaYoke=$d0, Length=0mm, Skew=0deg, Slots=$slots, SlotType=2, Hs0=$hso, Hs01=0mm, Hs1=$hs1, Hs2=$hs2, Bs0=$bs0, Bs1=$bs1, Bs2=$bs2, Rs=$rs, FilletType=0, HalfSlot=0, SegAngle=15deg, LenRegion=0mm, InfoCore=0)
  rotor [Cogent Power - M250-35A, B-H at 50Hz] = user_primitive(RMxprt/PMCore.dll, DiaGap=$dro, DiaYoke=$dri, Length=0mm, Poles=$P, PoleType=1, Embrace=$ep, ThickMag=$tm, WidthMag=$wm, Offset=0mm, Bridge=0mm, Rib=$rib, LenRegion=0mm, InfoCore=0)
  magents [vacuum, oriented by FaceCS1] = user_primitive(RMxprt/PMCore.dll, DiaGap=$dro, DiaYoke=$dri, Length=0mm, Poles=$P, PoleType=1, Embrace=$ep, ThickMag=$tm, WidthMag=$wm, Offset=0mm, Bridge=0mm, Rib=$rib, LenRegion=0mm, InfoCore=2)
  coordinate_system FaceCS1 = face of magents: Origin=(23.688077, 23.688077, 0) FaceID=magents.face(at (22.6635, 22.6635, 0)) AxisPosn=(26.162951, 26.162951, 0) WhichAxis=X ZRotationAngle=0deg XOffset=0mm YOffset=0mm FaceNormal(0, 0, 1)
  magents_1 [vacuum, oriented by FaceCS2] = magents.duplicate_around_axis(axis=Z, angle=2*pi/$P, total=2)
  coordinate_system FaceCS2 = face of magents_1: Origin=(-23.688077, 23.688077, 0) FaceID=magents_1.face(1 of 1) AxisPosn=(-26.162951, 26.162951, 0) WhichAxis=X ZRotationAngle=0deg XOffset=0mm YOffset=0mm FaceNormal(0, 0, 1)
  magents_2 [vacuum, oriented by FaceCS3] = magents.duplicate_around_axis(axis=Z, angle=2*2*pi/$P, total=2)
  coordinate_system FaceCS3 = face of magents_2: Origin=(-23.688077, -23.688077, 0) FaceID=magents_2.face(1 of 1) AxisPosn=(-26.162951, -26.162951, 0) WhichAxis=X ZRotationAngle=0deg XOffset=0mm YOffset=0mm FaceNormal(0, 0, 1)
  magents_1_1 [vacuum, oriented by FaceCS4] = magents_1.duplicate_around_axis(axis=Z, angle=2*2*pi/$P, total=2)
  coordinate_system FaceCS4 = face of magents_1_1: Origin=(23.688077, -23.688077, 0) FaceID=magents_1_1.face(1 of 1) AxisPosn=(26.162951, -26.162951, 0) WhichAxis=X ZRotationAngle=0deg XOffset=0mm YOffset=0mm FaceNormal(0, 0, 1)
  R_10 [copper] = user_primitive(RMxprt/LapCoil.dll, DiaGap=$di, DiaYoke=$d0, Length=0mm, Skew=0deg, Slots=$slots, SlotType=2, Hs0=$hso, Hs1=$hs1, Hs2=$hs2, Bs0=$bs0, Bs1=$bs1, Bs2=$bs2, Rs=$rs, FilletType=0, Layers=2, CoilPitch=6, EndExt=0mm, SpanExt=0mm, BendAngle=0deg, SegAngle=0deg, LenRegion=0mm, InfoCoil=0)
  R_7, Y_1, Y_5, Y_8, Y_6, B_12, B_13, B, B_14, R, R_12, R_14, R_5, Y_15, Y_7, Y_10, Y_9, B_11, B_7, B_9, B_6, R_11, R_8, R_6, R_13, Y_13, Y_2, Y_4, Y_12, B_1, B_8, B_10, B_15, R_3, R_1, R_4, R_9, Y_3, Y_14, Y_11, Y, B_2..B_5, R_2, R_15 [copper] = R_10.separate_bodies()
  region [vacuum] = circle(normal=Z, centre=(0mm, 0mm, 0mm), radius=61.554854mm)
  band [vacuum] = polyline((0mm, 0mm, 0mm) (37.15mm, 0mm, 0mm))
  band.sweep_around_axis(axis=Z, angle=360deg)
motion:
  MotionSetup1: Band Move_Type=Rotate Coordinate_System=Global Axis=Z Is_Positive=true InitPos=$alignment Angular_Velocity=0rpm Moment_of_Inertia=0.0003 Damping=0.02 Load_Torque=-5NewtonMeter Objects=band
  Moving1: Moving Objects=[rotor, magents, magents_1, magents_2, magents_1_1]
boundaries and excitations:
  VectorPotential1: Vector Potential Edges=region.edge(at (-61.5549, 0, 0)) Value=0
  R_2: Coil Objects=R_2 Conductor_number=$tc Winding=PhaseA PolarityType=Positive
  R_1: Coil Objects=R_1 Conductor_number=$tc Winding=PhaseA PolarityType=Positive
  R_10: Coil Objects=R_10 Conductor_number=$tc Winding=PhaseA PolarityType=Positive
  R_9: Coil Objects=R_9 Conductor_number=$tc Winding=PhaseA PolarityType=Positive
  R_11: Coil Objects=R_11 Conductor_number=$tc Winding=PhaseA PolarityType=Positive
  R_12: Coil Objects=R_12 Conductor_number=$tc Winding=PhaseA PolarityType=Positive
  R_5: Coil Objects=R_5 Conductor_number=$tc Winding=PhaseA PolarityType=Positive
  R_6: Coil Objects=R_6 Conductor_number=$tc Winding=PhaseA PolarityType=Positive
  R_14: Coil Objects=R_14 Conductor_number=$tc Winding=PhaseA PolarityType=Negative
  R_7: Coil Objects=R_7 Conductor_number=$tc Winding=PhaseA PolarityType=Negative
  R_15: Coil Objects=R_15 Conductor_number=$tc Winding=PhaseA PolarityType=Negative
  R: Coil Objects=R Conductor_number=$tc Winding=PhaseA PolarityType=Negative
  R_3: Coil Objects=R_3 Conductor_number=$tc Winding=PhaseA PolarityType=Negative
  R_8: Coil Objects=R_8 Conductor_number=$tc Winding=PhaseA PolarityType=Negative
  R_4: Coil Objects=R_4 Conductor_number=$tc Winding=PhaseA PolarityType=Negative
  R_13: Coil Objects=R_13 Conductor_number=$tc Winding=PhaseA PolarityType=Negative
  B_12: Coil Objects=B_12 Conductor_number=$tc Winding=phaseB PolarityType=Positive
  B_3: Coil Objects=B_3 Conductor_number=$tc Winding=phaseB PolarityType=Positive
  B_5: Coil Objects=B_5 Conductor_number=$tc Winding=phaseB PolarityType=Positive
  B: Coil Objects=B Conductor_number=$tc Winding=phaseB PolarityType=Positive
  B_1: Coil Objects=B_1 Conductor_number=$tc Winding=phaseB PolarityType=Positive
  B_7: Coil Objects=B_7 Conductor_number=$tc Winding=phaseB PolarityType=Positive
  B_10: Coil Objects=B_10 Conductor_number=$tc Winding=phaseB PolarityType=Positive
  B_6: Coil Objects=B_6 Conductor_number=$tc Winding=phaseB PolarityType=Positive
  B_11: Coil Objects=B_11 Conductor_number=$tc Winding=phaseB PolarityType=Negative
  B_13: Coil Objects=B_13 Conductor_number=$tc Winding=phaseB PolarityType=Negative
  B_14: Coil Objects=B_14 Conductor_number=$tc Winding=phaseB PolarityType=Negative
  B_9: Coil Objects=B_9 Conductor_number=$tc Winding=phaseB PolarityType=Negative
  B_4: Coil Objects=B_4 Conductor_number=$tc Winding=phaseB PolarityType=Negative
  B_15: Coil Objects=B_15 Conductor_number=$tc Winding=phaseB PolarityType=Negative
  B_2: Coil Objects=B_2 Conductor_number=$tc Winding=phaseB PolarityType=Negative
  B_8: Coil Objects=B_8 Conductor_number=$tc Winding=phaseB PolarityType=Negative
  Y_1: Coil Objects=Y_1 Conductor_number=$tc Winding=phaseC PolarityType=Negative
  Y_14: Coil Objects=Y_14 Conductor_number=$tc Winding=phaseC PolarityType=Negative
  Y_8: Coil Objects=Y_8 Conductor_number=$tc Winding=phaseC PolarityType=Negative
  Y: Coil Objects=Y Conductor_number=$tc Winding=phaseC PolarityType=Negative
  Y_7: Coil Objects=Y_7 Conductor_number=$tc Winding=phaseC PolarityType=Negative
  Y_13: Coil Objects=Y_13 Conductor_number=$tc Winding=phaseC PolarityType=Negative
  Y_4: Coil Objects=Y_4 Conductor_number=$tc Winding=phaseC PolarityType=Negative
  Y_9: Coil Objects=Y_9 Conductor_number=$tc Winding=phaseC PolarityType=Negative
  Y_15: Coil Objects=Y_15 Conductor_number=$tc Winding=phaseC PolarityType=Positive
  Y_5: Coil Objects=Y_5 Conductor_number=$tc Winding=phaseC PolarityType=Positive
  Y_6: Coil Objects=Y_6 Conductor_number=$tc Winding=phaseC PolarityType=Positive
  Y_10: Coil Objects=Y_10 Conductor_number=$tc Winding=phaseC PolarityType=Positive
  Y_3: Coil Objects=Y_3 Conductor_number=$tc Winding=phaseC PolarityType=Positive
  Y_2: Coil Objects=Y_2 Conductor_number=$tc Winding=phaseC PolarityType=Positive
  Y_11: Coil Objects=Y_11 Conductor_number=$tc Winding=phaseC PolarityType=Positive
  Y_12: Coil Objects=Y_12 Conductor_number=$tc Winding=phaseC PolarityType=Positive
  PhaseA: Winding Group Type=Voltage IsSolid=false Current=0 Resistance=2ohm Inductance=0nH Voltage=1.414*$vph*sin(2*pi*50*time) ParallelBranchesNum=2
  phaseB: Winding Group Type=Voltage IsSolid=false Current=0 Resistance=2ohm Inductance=0nH Voltage=1.414*$vph*sin(2*pi*50*time-2*pi/3) ParallelBranchesNum=2
  phaseC: Winding Group Type=Voltage IsSolid=false Current=0 Resistance=2ohm Inductance=0nH Voltage=1.414*$vph*sin(2*pi*50*time-4*pi/3) ParallelBranchesNum=2
mesh:
  CylindricalGap1: CylindricalGap Objects=band Objects=band
setups:
  Setup1: Transient NonlinearSolverResidual=0.0001 StopTime=400ms TimeStep="(0.02/30) s" SaveFieldsType="Every N Steps" N_Steps=1 Steps_From=100ms Steps_To=400ms NumberSolveSteps=1 RangeStart=0s RangeEnd=0.1s InitialTimeStep=0.002s MinTimeStep=0.001s MaxTimeStep=0.003s TimeStepErrTolerance=0.0001
field plots:
  Flux_Lines1: A over stator, rotor, magents, magents_1, magents_2, magents_1_1, R_10, R_7, Y_1, Y_5, Y_8, Y_6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 on Setup1 : Transient at Time=100ms
  B_Vector1: B over stator, rotor, magents, magents_1, magents_2, magents_1_1, R_10, R_7, Y_1, Y_5, Y_8, Y_6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 on Setup1 : Transient at Time=100ms
  Mag_B1: B over stator, rotor, magents, magents_1, magents_2, magents_1_1, R_10, R_7, Y_1, Y_5, Y_8, Y_6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 on Setup1 : Transient at Time=176000000ns
reports:
  Torque Plot1: Moving1.Torque vs Time on Setup1 : Transient
  Speed Plot1: Moving1.Speed vs Time on Setup1 : Transient
  Position Plot1: Moving1.Position vs Time on Setup1 : Transient
  Winding Plot1: FluxLinkage(PhaseA), FluxLinkage(phaseB), FluxLinkage(phaseC) vs Time on Setup1 : Transient
  Winding Plot2: InducedVoltage(PhaseA), InducedVoltage(phaseB), InducedVoltage(phaseC) vs Time on Setup1 : Transient
  Winding Plot3: Current(PhaseA), Current(phaseB), Current(phaseC) vs Time on Setup1 : Transient [$alignment=all]
