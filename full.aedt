# Ansys Electronics Desktop project, version 2025.1
materials:
  vacuum: permittivity=1
  Cogent Power - M250-35A, B-H at 50Hz: core_loss_curve{50Hz (0, 0) (0.05, 0.01) (0.1, 0.02) (0.15, 0.04) (0.2, 0.06) (0.25, 0.095) (0.3, 0.13) (0.35, 0.17) (0.4, 0.21) (0.45, 0.26) (0.5, 0.31) (0.55, 0.36) (0.6, 0.41) (0.65, 0.465) (0.7, 0.52) (0.75, 0.59) (0.8, 0.66) (0.85, 0.735) (0.9, 0.81) (0.95, 0.895) (1, 0.98) (1.05, 1.065) (1.1, 1.15) (1.15, 1.26) (1.2, 1.37) (1.25, 1.51) (1.3, 1.65) (1.35, 1.825) (1.4, 2) (1.45, 2.175) (1.5, 2.35) (1.55, 2.5) (1.6, 2.65) (1.65, 2.76) (1.7, 2.87) (1.75, 2.965) (1.8, 3.06)} core_loss_curve{100Hz (0, 0) (0.05, 0.02) (0.1, 0.04) (0.15, 0.09) (0.2, 0.14) (0.25, 0.225) (0.3, 0.31) (0.35, 0.41) (0.4, 0.51) (0.45, 0.63) (0.5, 0.75) (0.55, 0.88) (0.6, 1.01) (0.65, 1.16) (0.7, 1.31) (0.75, 1.475) (0.8, 1.64) (0.85, 1.82) (0.9, 2) (0.95, 2.205) (1, 2.41) (1.05, 2.64) (1.1, 2.87) (1.15, 3.135) (1.2, 3.4) (1.25, 3.715) (1.3, 4.03) (1.35, 4.43) (1.4, 4.83) (1.45, 5.275) (1.5, 5.72) (1.55, 6.165) (1.6, 6.61) (1.65, 7.055) (1.7, 7.5) (1.75, 7.945) (1.8, 8.39)} core_loss_curve{200Hz (0, 0) (0.05, 0.04) (0.1, 0.08) (0.15, 0.205) (0.2, 0.33) (0.25, 0.53) (0.3, 0.73) (0.35, 0.98) (0.4, 1.23) (0.45, 1.525) (0.5, 1.82) (0.55, 2.155) (0.6, 2.49) (0.65, 2.875) (0.7, 3.26) (0.75, 3.69) (0.8, 4.12) (0.85, 4.595) (0.9, 5.07) (0.95, 5.605) (1, 6.14) (1.05, 6.735) (1.1, 7.33) (1.15, 8.01) (1.2, 8.69) (1.25, 9.495) (1.3, 10.3) (1.35, 11.35) (1.4, 12.4) (1.45, 13.55) (1.5, 14.7) (1.55, 15.85) (1.6, 17) (1.65, 18.15) (1.7, 19.3) (1.75, 20.45) (1.8, 21.6)} core_loss_curve{400Hz (0, 0) (0.05, 0.105) (0.1, 0.21) (0.15, 0.555) (0.2, 0.9) (0.25, 1.415) (0.3, 1.93) (0.35, 2.585) (0.4, 3.24) (0.45, 4.025) (0.5, 4.81) (0.55, 5.75) (0.6, 6.69) (0.65, 7.755) (0.7, 8.82) (0.75, 10.01) (0.8, 11.2) (0.85, 12.6) (0.9, 14) (0.95, 15.55) (1, 17.1) (1.05, 18.85) (1.1, 20.6) (1.15, 22.6) (1.2, 24.6) (1.25, 26.9) (1.3, 29.2) (1.35, 32.15) (1.4, 35.1) (1.45, 38.35) (1.5, 41.6) (1.55, 44.85) (1.6, 48.1) (1.65, 51.35) (1.7, 54.6) (1.75, 57.85) (1.8, 61.1)} core_loss_curve{1000Hz (0, 0) (0.05, 0.49) (0.1, 0.98) (0.15, 2.315) (0.2, 3.65) (0.25, 5.615) (0.3, 7.58) (0.35, 10.14) (0.4, 12.7) (0.45, 15.75) (0.5, 18.8) (0.55, 22.55) (0.6, 26.3) (0.65, 30.75) (0.7, 35.2) (0.75, 40.45) (0.8, 45.7) (0.85, 51.9) (0.9, 58.1) (0.95, 65.35) (1, 72.6) (1.05, 81.1) (1.1, 89.6) (1.15, 98.1) (1.2, 106.6) (1.25, 115.1) (1.3, 123.6) (1.35, 132.1) (1.4, 140.6) (1.45, 149.1) (1.5, 157.6) (1.55, 166.1) (1.6, 174.6) (1.65, 183.1) (1.7, 191.6) (1.75, 200.1) (1.8, 208.6)} permeability{HUnit=A_per_meter BUnit=tesla curve (0, 0) (5, 0.00973865) (10, 0.0213622) (15, 0.037698) (20, 0.0578036) (26.8, 0.1) (35.7, 0.2) (41.8, 0.3) (47.5, 0.4) (53.4, 0.5) (60, 0.6) (67.9, 0.7) (77.5, 0.8) (90, 0.9) (107, 1) (133, 1.1) (179, 1.2) (284, 1.3) (642, 1.4) (1810, 1.5) (4030, 1.6) (7290, 1.7) (11700, 1.8) (23345, 1.9396) (46579, 2.0315) (92937, 2.1211) (185430, 2.2531) (369980, 2.4929) (738210, 2.9596)} conductivity=1818180 core_loss_type="Power Ferrite" core_loss_cm=32.3209 core_loss_x=1.78587 core_loss_y=1.39979 mass_density=7650 stacking_type=Lamination stacking_factor=0.95 stacking_direction=V(3)
  Arnold_Magnetics_N42EH_100C: permeability{HUnit=A_per_meter BUnit=tesla curve (-1526000, -1.9844) (-1523000, -1.4535) (-1512000, -1.0379) (-1490000, -0.8648) (-1472000, -0.8059) (-1454000, -0.7638) (-1436000, -0.729) (-1418000, -0.6978) (-1400000, -0.6688) (-1382000, -0.6412) (-1364000, -0.6145) (-1346000, -0.5885) (-1328000, -0.5629) (-1310000, -0.5378) (-1292000, -0.5128) (-1274000, -0.4881) (-1256000, -0.4636) (-1239000, -0.4393) (-1221000, -0.415) (-1203000, -0.3909) (-1185000, -0.3668) (-1167000, -0.3428) (-1149000, -0.3189) (-1131000, -0.295) (-1113000, -0.2711) (-1095000, -0.2473) (-1077000, -0.2236) (-1059000, -0.1999) (-1041000, -0.1762) (-1023000, -0.1525) (-1005000, -0.1288) (-987000, -0.1052) (-969000, -0.0816) (-951000, -0.058) (-933000, -0.0344) (-915000, -0.0108) (-897000, 0.0127) (-880000, 0.0363) (-862000, 0.0598) (-844000, 0.0833) (-826000, 0.1068) (-808000, 0.1304) (-790000, 0.1538) (-772000, 0.1773) (-754000, 0.2008) (-736000, 0.2243) (-718000, 0.2478) (-700000, 0.2712) (-682000, 0.2947) (-664000, 0.3182) (-646000, 0.3416) (-628000, 0.3651) (-610000, 0.3885) (-592000, 0.4119) (-574000, 0.4354) (-556000, 0.4588) (-538000, 0.4822) (-521000, 0.5057) (-503000, 0.5291) (-485000, 0.5525) (-467000, 0.5759) (-449000, 0.5994) (-431000, 0.6228) (-413000, 0.6462) (-395000, 0.6696) (-377000, 0.693) (-359000, 0.7164) (-341000, 0.7398) (-323000, 0.7632) (-305000, 0.7866) (-287000, 0.81) (-269000, 0.8334) (-251000, 0.8568) (-233000, 0.8802) (-215000, 0.9036) (-197000, 0.927) (-179000, 0.9504) (-162000, 0.9738) (-144000, 0.9972) (-126000, 1.0206) (-108000, 1.0439) (-90000, 1.0673) (-72000, 1.0907) (-54000, 1.1141) (-36000, 1.1375) (-18000, 1.1609) (0, 1.1842)} conductivity=555555.5556 magnetic_coercivity{Magnitude=-1022100A_per_meter DirComp1=1 DirComp2=0 DirComp3=0}
  Arnold_Magnetics_N42EH_100C_s: permeability{HUnit=A_per_meter BUnit=tesla curve (-1526000, -1.9844) (-1523000, -1.4535) (-1512000, -1.0379) (-1490000, -0.8648) (-1472000, -0.8059) (-1454000, -0.7638) (-1436000, -0.729) (-1418000, -0.6978) (-1400000, -0.6688) (-1382000, -0.6412) (-1364000, -0.6145) (-1346000, -0.5885) (-1328000, -0.5629) (-1310000, -0.5378) (-1292000, -0.5128) (-1274000, -0.4881) (-1256000, -0.4636) (-1239000, -0.4393) (-1221000, -0.415) (-1203000, -0.3909) (-1185000, -0.3668) (-1167000, -0.3428) (-1149000, -0.3189) (-1131000, -0.295) (-1113000, -0.2711) (-1095000, -0.2473) (-1077000, -0.2236) (-1059000, -0.1999) (-1041000, -0.1762) (-1023000, -0.1525) (-1005000, -0.1288) (-987000, -0.1052) (-969000, -0.0816) (-951000, -0.058) (-933000, -0.0344) (-915000, -0.0108) (-897000, 0.0127) (-880000, 0.0363) (-862000, 0.0598) (-844000, 0.0833) (-826000, 0.1068) (-808000, 0.1304) (-790000, 0.1538) (-772000, 0.1773) (-754000, 0.2008) (-736000, 0.2243) (-718000, 0.2478) (-700000, 0.2712) (-682000, 0.2947) (-664000, 0.3182) (-646000, 0.3416) (-628000, 0.3651) (-610000, 0.3885) (-592000, 0.4119) (-574000, 0.4354) (-556000, 0.4588) (-538000, 0.4822) (-521000, 0.5057) (-503000, 0.5291) (-485000, 0.5525) (-467000, 0.5759) (-449000, 0.5994) (-431000, 0.6228) (-413000, 0.6462) (-395000, 0.6696) (-377000, 0.693) (-359000, 0.7164) (-341000, 0.7398) (-323000, 0.7632) (-305000, 0.7866) (-287000, 0.81) (-269000, 0.8334) (-251000, 0.8568) (-233000, 0.8802) (-215000, 0.9036) (-197000, 0.927) (-179000, 0.9504) (-162000, 0.9738) (-144000, 0.9972) (-126000, 1.0206) (-108000, 1.0439) (-90000, 1.0673) (-72000, 1.0907) (-54000, 1.1141) (-36000, 1.1375) (-18000, 1.1609) (0, 1.1842)} conductivity=555555.5556 magnetic_coercivity{Magnitude=-1022100A_per_meter DirComp1=-1 DirComp2=0 DirComp3=0}
  copper: permeability=0.999991 conductivity=58000000

design Maxwell2DDesign1 (Maxwell 2D, Transient, XY geometry, model units mm)
options: ComputeTransientInductance ModelDepth=l EnableTranTranLinkWithSimplorer
variables:
  d = 96mm
  do = 160mm
  qs = 24
  hs0 = 1mm
  hs1 = 1mm
  hs2 = 14mm
  bs0 = 1mm
  bs1 = 4.7mm
  bs2 = 7mm
  lg = 0.7mm
  dsh = 20mm
  ep = 0.9
  tpm = 4mm
  p = 4
  conductors = 42
  alignment = 7.5deg
  Ns = 1000rpm
  l = 50mm
  iph = 10A
  is = 10A
  alpha = 0deg
  skew = 0deg
  Vph_rms = 230V
  RS = 4.07e-05ohm
  kl = 0NewtonMeter
geometry:
  stator [Cogent Power - M250-35A, B-H at 50Hz] = user_primitive(RMxprt/SlotCore.dll, DiaGap=d, DiaYoke=do, Length=0mm, Skew=skew, Slots=qs, SlotType=2, Hs0=hs0, Hs01=0mm, Hs1=hs1, Hs2=hs2, Bs0=bs0, Bs1=bs1, Bs2=bs2, Rs=0mm, FilletType=0, HalfSlot=0, SegAngle=0deg, LenRegion=0mm, InfoCore=0)
  rotor [Cogent Power - M250-35A, B-H at 50Hz] = user_primitive(RMxprt/PMCore.dll, DiaGap=d-2*lg, DiaYoke=dsh, Length=0mm, Poles=p, PoleType=1, Embrace=ep, ThickMag=tpm, WidthMag=0mm, Offset=0mm, Bridge=0mm, Rib=0mm, LenRegion=0mm, InfoCore=0)
  pm [Arnold_Magnetics_N42EH_100C, oriented by FaceCS1] = user_primitive(RMxprt/PMCore.dll, DiaGap=d-2*lg, DiaYoke=dsh, Length=0mm, Poles=4, PoleType=1, Embrace=ep, ThickMag=tpm, WidthMag=0mm, Offset=0mm, Bridge=0mm, Rib=0mm, LenRegion=0mm, InfoCore=2)
  coordinate_system FaceCS1 = face of pm: Origin=(30.617724, 30.617724, 0) FaceID=pm.face(at (28.364, 28.364, 0)) AxisPosn=(33.446151, 33.446151, 0) WhichAxis=X ZRotationAngle=0deg XOffset=0mm YOffset=0mm FaceNormal(0, 0, 1)
  pm_1 [Arnold_Magnetics_N42EH_100C_s, oriented by FaceCS2] = pm.duplicate_around_axis(axis=Z, angle=2*pi/p, total=2)
  coordinate_system FaceCS2 = face of pm_1: Origin=(-30.617724, 30.617724, 0) FaceID=pm_1.face(1 of 1) AxisPosn=(-33.446151, 33.446151, 0) WhichAxis=X ZRotationAngle=0deg XOffset=0mm YOffset=0mm FaceNormal(0, 0, 1)
  pm_2 [Arnold_Magnetics_N42EH_100C, oriented by FaceCS3] = pm.duplicate_around_axis(axis=Z, angle=2*2*pi/p, total=2)
  coordinate_system FaceCS3 = face of pm_2: Origin=(-30.617724, -30.617724, 0) FaceID=pm_2.face(1 of 1) AxisPosn=(-33.446151, -33.446151, 0) WhichAxis=X ZRotationAngle=0deg XOffset=0mm YOffset=0mm FaceNormal(0, 0, 1)
  pm_1_1 [Arnold_Magnetics_N42EH_100C_s, oriented by FaceCS4] = pm_1.duplicate_around_axis(axis=Z, angle=2*2*pi/p, total=2)
  coordinate_system FaceCS4 = face of pm_1_1: Origin=(30.617724, -30.617724, 0) FaceID=pm_1_1.face(1 of 1) AxisPosn=(33.446151, -33.446151, 0) WhichAxis=X ZRotationAngle=0deg XOffset=0mm YOffset=0mm FaceNormal(0, 0, 1)
  A_3 [copper] = user_primitive(RMxprt/LapCoil.dll, DiaGap=d, DiaYoke=do, Length=0mm, Skew=0deg, Slots=qs, SlotType=2, Hs0=hs0, Hs1=hs1, Hs2=hs2, Bs0=bs0, Bs1=bs1, Bs2=bs2, Rs=0mm, FilletType=0, Layers=2, CoilPitch=6, EndExt=0mm, SpanExt=0mm, BendAngle=0deg, SegAngle=0deg, LenRegion=0mm, InfoCoil=0)
  A, C, C_6, C_14, C_5, B_4, B_7, B_11, B_15, A_6, A_13, A_1, A_9, C_4, C_11, C_13, C_1, B_8, B_12, B_2, B_3, A_8, A_10, A_11, A_14, C_2, C_7, C_12, C_3, B_9, B_1, B_10, B_13, A_2, A_12, A_15, A_7, C_8, C_9, C_15, C_10, B_14, B_6, B_5, B, A_4, A_5 [copper] = A_3.separate_bodies()
  band [vacuum] = polyline((0mm, 0mm, 0mm) (d/2-lg+0.15mm, 0mm, 0mm))
  band.sweep_around_axis(axis=Z, angle=360deg)
  region [vacuum] = circle(normal=Z, centre=(0mm, 0mm, 0mm), radius=do/2+3mm)
  AG_arc = polyline(z=0mm, xy: (d/2-lg/2, 0mm) (-47.648186mm, 0.41581942mm) (47.642743mm, -0.83160717mm), AngularArc from point 0 over 3 centre=(0mm, 0mm, 0mm) angle=359deg plane=XY)
motion:
  MotionSetup1: Band Move_Type=Rotate Coordinate_System=Global Axis=Z Is_Positive=true InitPos=alignment Angular_Velocity=0rpm Objects=band
  Moving1: Moving Objects=[rotor, pm, pm_1, pm_2, pm_1_1]
boundaries and excitations:
  VectorPotential1: Vector Potential Edges=region.edge(at (-83, 0, 0)) Value=0
  A_7: Coil Objects=A_7 Conductor_number=conductors Winding=PhaseA PolarityType=Positive
  A_3: Coil Objects=A_3 Conductor_number=conductors Winding=PhaseA PolarityType=Positive
  A_4: Coil Objects=A_4 Conductor_number=conductors Winding=PhaseA PolarityType=Positive
  A_12: Coil Objects=A_12 Conductor_number=conductors Winding=PhaseA PolarityType=Positive
  A_8: Coil Objects=A_8 Conductor_number=conductors Winding=PhaseA PolarityType=Positive
  A_13: Coil Objects=A_13 Conductor_number=conductors Winding=PhaseA PolarityType=Positive
  A_9: Coil Objects=A_9 Conductor_number=conductors Winding=PhaseA PolarityType=Positive
  A_11: Coil Objects=A_11 Conductor_number=conductors Winding=PhaseA PolarityType=Positive
  A_6: Coil Objects=A_6 Conductor_number=conductors Winding=PhaseA PolarityType=Negative
  A_5: Coil Objects=A_5 Conductor_number=conductors Winding=PhaseA PolarityType=Negative
  A: Coil Objects=A Conductor_number=conductors Winding=PhaseA PolarityType=Negative
  A_1: Coil Objects=A_1 Conductor_number=conductors Winding=PhaseA PolarityType=Negative
  A_2: Coil Objects=A_2 Conductor_number=conductors Winding=PhaseA PolarityType=Negative
  A_15: Coil Objects=A_15 Conductor_number=conductors Winding=PhaseA PolarityType=Negative
  A_10: Coil Objects=A_10 Conductor_number=conductors Winding=PhaseA PolarityType=Negative
  A_14: Coil Objects=A_14 Conductor_number=conductors Winding=PhaseA PolarityType=Negative
  C: Coil Objects=C Conductor_number=conductors Winding=PhaseC PolarityType=Negative
  C_9: Coil Objects=C_9 Conductor_number=conductors Winding=PhaseC PolarityType=Negative
  C_10: Coil Objects=C_10 Conductor_number=conductors Winding=PhaseC PolarityType=Negative
  C_14: Coil Objects=C_14 Conductor_number=conductors Winding=PhaseC PolarityType=Negative
  C_2: Coil Objects=C_2 Conductor_number=conductors Winding=PhaseC PolarityType=Negative
  C_11: Coil Objects=C_11 Conductor_number=conductors Winding=PhaseC PolarityType=Negative
  C_1: Coil Objects=C_1 Conductor_number=conductors Winding=PhaseC PolarityType=Negative
  C_12: Coil Objects=C_12 Conductor_number=conductors Winding=PhaseC PolarityType=Negative
  C_6: Coil Objects=C_6 Conductor_number=conductors Winding=PhaseC PolarityType=Positive
  C_4: Coil Objects=C_4 Conductor_number=conductors Winding=PhaseC PolarityType=Positive
  C_5: Coil Objects=C_5 Conductor_number=conductors Winding=PhaseC PolarityType=Positive
  C_13: Coil Objects=C_13 Conductor_number=conductors Winding=PhaseC PolarityType=Positive
  C_8: Coil Objects=C_8 Conductor_number=conductors Winding=PhaseC PolarityType=Positive
  C_15: Coil Objects=C_15 Conductor_number=conductors Winding=PhaseC PolarityType=Positive
  C_3: Coil Objects=C_3 Conductor_number=conductors Winding=PhaseC PolarityType=Positive
  C_7: Coil Objects=C_7 Conductor_number=conductors Winding=PhaseC PolarityType=Positive
  B: Coil Objects=B Conductor_number=conductors Winding=PhaseB PolarityType=Positive
  B_11: Coil Objects=B_11 Conductor_number=conductors Winding=PhaseB PolarityType=Positive
  B_4: Coil Objects=B_4 Conductor_number=conductors Winding=PhaseB PolarityType=Positive
  B_6: Coil Objects=B_6 Conductor_number=conductors Winding=PhaseB PolarityType=Positive
  B_9: Coil Objects=B_9 Conductor_number=conductors Winding=PhaseB PolarityType=Positive
  B_12: Coil Objects=B_12 Conductor_number=conductors Winding=PhaseB PolarityType=Positive
  B_10: Coil Objects=B_10 Conductor_number=conductors Winding=PhaseB PolarityType=Positive
  B_3: Coil Objects=B_3 Conductor_number=conductors Winding=PhaseB PolarityType=Positive
  B_2: Coil Objects=B_2 Conductor_number=conductors Winding=PhaseB PolarityType=Negative
  B_15: Coil Objects=B_15 Conductor_number=conductors Winding=PhaseB PolarityType=Negative
  B_7: Coil Objects=B_7 Conductor_number=conductors Winding=PhaseB PolarityType=Negative
  B_8: Coil Objects=B_8 Conductor_number=conductors Winding=PhaseB PolarityType=Negative
  B_14: Coil Objects=B_14 Conductor_number=conductors Winding=PhaseB PolarityType=Negative
  B_1: Coil Objects=B_1 Conductor_number=conductors Winding=PhaseB PolarityType=Negative
  B_5: Coil Objects=B_5 Conductor_number=conductors Winding=PhaseB PolarityType=Negative
  B_13: Coil Objects=B_13 Conductor_number=conductors Winding=PhaseB PolarityType=Negative
  PhaseA: Winding Group Type=External IsSolid=false Current=0 ParallelBranchesNum=1
  PhaseB: Winding Group Type=External IsSolid=false Current=0 ParallelBranchesNum=1
  PhaseC: Winding Group Type=External IsSolid=false Current=0 ParallelBranchesNum=1
  eddy effects on: pm, pm_1, pm_2, pm_1_1
  core loss on: stator, rotor
mesh:
  CylindricalGap1: CylindricalGap Objects=band Objects=band
setups:
  dynamic: Transient NonlinearSolverResidual=0.0001 StopTime=100ms TimeStep=1ms InitialTimeStep=0.002s MinTimeStep=0.001s MaxTimeStep=0.003s TimeStepErrTolerance=0.0001
optimetrics:
  ParametricSetup1: Parametric InterpolationPoints=0 Sim._Setups=[dynamic]
    sweep kl: 0NewtonMeter
output variables:
  power = Moving1.Torque*Moving1.Speed
  pos = (Moving1.Position -7.5 * PI/180) * 2 + PI
  sin0 = -sin(pos)
  sin1 = -sin(pos-2*PI/3)
  sin2 = -sin(pos-4*PI/3)
  cos0 = cos(pos)
  cos1 = cos(pos-2*PI/3)
  cos2 = cos(pos-4*PI/3)
  Flux_d = (FluxLinkage(PhaseA)*cos0+FluxLinkage(PhaseB)*cos1+FluxLinkage(PhaseC)*cos2)*2/3
  Flux_q = (FluxLinkage(PhaseA)*sin0+FluxLinkage(PhaseB)*sin1+FluxLinkage(PhaseC)*sin2)*2/3
  I_d = (Current(PhaseA)*cos0 + Current(PhaseB)*cos1 + Current(PhaseC)*cos2)*2/3
  I_q = (Current(PhaseA)*sin0 + Current(PhaseB)*sin1 + Current(PhaseC)*sin2)*2/3
  Irms = sqrt(I_d^2+I_q^2)/sqrt(2)
  Lad = L(PhaseA,PhaseA)*cos0 + L(PhaseA,PhaseB)*cos1 + L(PhaseA,PhaseC)*cos2
  Laq = L(PhaseA,PhaseA)*sin0 + L(PhaseA,PhaseB)*sin1 + L(PhaseA,PhaseC)*sin2
  Lbd = L(PhaseB,PhaseA)*cos0 + L(PhaseB,PhaseB)*cos1 + L(PhaseB,PhaseC)*cos2
  Lbq = L(PhaseB,PhaseA)*sin0 + L(PhaseB,PhaseB)*sin1 + L(PhaseB,PhaseC)*sin2
  Lcd = L(PhaseC,PhaseA)*cos0 + L(PhaseC,PhaseB)*cos1 + L(PhaseC,PhaseC)*cos2
  Lcq = L(PhaseC,PhaseA)*sin0 + L(PhaseC,PhaseB)*sin1 + L(PhaseC,PhaseC)*sin2
  L_d = (Lad*cos0 + Lbd*cos1 + Lcd*cos2) * 2/3
  L_q = (Laq*sin0 + Lbq*sin1 + Lcq*sin2) * 2/3
field calculator expressions:
  Bradial = Fundamental_Quantity(22) | ScalarX | Scalar_Function(FuncValue='PHI') | UMathFunc | * | Fundamental_Quantity(22) | ScalarY | Scalar_Function(FuncValue='PHI') | UMathFunc | * | +
reports:
  Torque Plot1: Moving1.Torque vs Time on dynamic : Transient [kl=all]
  Speed Plot1: Moving1.Speed vs Time on dynamic : Transient [kl=all]
  Winding Plot1: InducedVoltage(PhaseA) vs Time on dynamic : Transient [kl=all]
  Winding Plot2: Current(PhaseA) vs Time on dynamic : Transient [kl=all]

design magnetic_loading (Maxwell 2D, Magnetostatic, XY geometry, model units mm)
options: ModelDepth=l
variables:
  d = 96mm
  do = 160mm
  qs = 24
  hs0 = 1mm
  hs1 = 1mm
  hs2 = 14mm
  bs0 = 1mm
  bs1 = 4.7mm
  bs2 = 7mm
  lg = 0.7mm
  dsh = 20mm
  ep = 0.9
  tpm = 4mm
  p = 4
  conductors = 25
  alignment = 7.5deg
  Ns = 1000rpm
  l = 50mm
  iph = 10A
  is = 20A
  alpha = 0deg
  skew = 0deg
  Vph_rms = 230V
  RS = 4.07e-05ohm
geometry:
  stator [Cogent Power - M250-35A, B-H at 50Hz] = user_primitive(RMxprt/SlotCore.dll, DiaGap=d, DiaYoke=do, Length=0mm, Skew=skew, Slots=qs, SlotType=2, Hs0=hs0, Hs01=0mm, Hs1=hs1, Hs2=hs2, Bs0=bs0, Bs1=bs1, Bs2=bs2, Rs=0mm, FilletType=0, HalfSlot=0, SegAngle=0deg, LenRegion=0mm, InfoCore=0)
  rotor [Cogent Power - M250-35A, B-H at 50Hz] = user_primitive(RMxprt/PMCore.dll, DiaGap=d-2*lg, DiaYoke=dsh, Length=0mm, Poles=p, PoleType=1, Embrace=ep, ThickMag=tpm, WidthMag=0mm, Offset=0mm, Bridge=0mm, Rib=0mm, LenRegion=0mm, InfoCore=0)
  pm [Arnold_Magnetics_N42EH_100C_s, oriented by FaceCS1] = user_primitive(RMxprt/PMCore.dll, DiaGap=d-2*lg, DiaYoke=dsh, Length=0mm, Poles=4, PoleType=1, Embrace=ep, ThickMag=tpm, WidthMag=0mm, Offset=0mm, Bridge=0mm, Rib=0mm, LenRegion=0mm, InfoCore=2)
  coordinate_system FaceCS1 = face of pm: Origin=(30.617724, 30.617724, 0) FaceID=pm.face(at (28.364, 28.364, 0)) AxisPosn=(33.446151, 33.446151, 0) WhichAxis=X ZRotationAngle=0deg XOffset=0mm YOffset=0mm FaceNormal(0, 0, 1)
  pm_1 [Arnold_Magnetics_N42EH_100C, oriented by FaceCS2] = pm.duplicate_around_axis(axis=Z, angle=2*pi/p, total=2)
  coordinate_system FaceCS2 = face of pm_1: Origin=(-30.617724, 30.617724, 0) FaceID=pm_1.face(1 of 1) AxisPosn=(-33.446151, 33.446151, 0) WhichAxis=X ZRotationAngle=0deg XOffset=0mm YOffset=0mm FaceNormal(0, 0, 1)
  pm_2 [Arnold_Magnetics_N42EH_100C_s, oriented by FaceCS3] = pm.duplicate_around_axis(axis=Z, angle=2*2*pi/p, total=2)
  coordinate_system FaceCS3 = face of pm_2: Origin=(-30.617724, -30.617724, 0) FaceID=pm_2.face(1 of 1) AxisPosn=(-33.446151, -33.446151, 0) WhichAxis=X ZRotationAngle=0deg XOffset=0mm YOffset=0mm FaceNormal(0, 0, 1)
  pm_1_1 [Arnold_Magnetics_N42EH_100C, oriented by FaceCS4] = pm_1.duplicate_around_axis(axis=Z, angle=2*2*pi/p, total=2)
  coordinate_system FaceCS4 = face of pm_1_1: Origin=(30.617724, -30.617724, 0) FaceID=pm_1_1.face(1 of 1) AxisPosn=(33.446151, -33.446151, 0) WhichAxis=X ZRotationAngle=0deg XOffset=0mm YOffset=0mm FaceNormal(0, 0, 1)
  A_3 [copper] = user_primitive(RMxprt/LapCoil.dll, DiaGap=d, DiaYoke=do, Length=0mm, Skew=0deg, Slots=qs, SlotType=2, Hs0=hs0, Hs1=hs1, Hs2=hs2, Bs0=bs0, Bs1=bs1, Bs2=bs2, Rs=0mm, FilletType=0, Layers=2, CoilPitch=6, EndExt=0mm, SpanExt=0mm, BendAngle=0deg, SegAngle=0deg, LenRegion=0mm, InfoCoil=0)
  A, C, C_6, C_14, C_5, B_4, B_7, B_11, B_15, A_6, A_13, A_1, A_9, C_4, C_11, C_13, C_1, B_8, B_12, B_2, B_3, A_8, A_10, A_11, A_14, C_2, C_7, C_12, C_3, B_9, B_1, B_10, B_13, A_2, A_12, A_15, A_7, C_8, C_9, C_15, C_10, B_14, B_6, B_5, B, A_4, A_5 [copper] = A_3.separate_bodies()
  band [vacuum] = polyline((0mm, 0mm, 0mm) (d/2-lg+0.15mm, 0mm, 0mm))
  band.sweep_around_axis(axis=Z, angle=360deg)
  region [vacuum] = circle(normal=Z, centre=(0mm, 0mm, 0mm), radius=do/2+3mm)
  AG_arc = polyline(z=0mm, xy: (d/2-lg/2, 0mm) (-47.648186mm, 0.41581942mm) (47.642743mm, -0.83160717mm), AngularArc from point 0 over 3 centre=(0mm, 0mm, 0mm) angle=359deg plane=XY)
boundaries and excitations:
  VectorPotential1: Vector Potential Edges=region.edge(at (-83, 0, 0)) Value=0
mesh:
  CylindricalGap1: CylindricalGap Objects=band Objects=band
  Length1: LengthBased Edges=AG_arc.edge(at (-47.6482, 0.415819, 0)) band.edge(at (-47.45, 0, 0)) MaxLength=lg
  Length2: LengthBased RefineInside Objects=[stator, rotor, pm, pm_1, pm_2, pm_1_1, A_3, A, C, C_6, C_14, C_5, B_4, B_7, B_11, B_15, A_6, A_13, A_1, A_9, C_4, C_11, C_13, C_1, B_8, B_12, B_2, B_3, A_8, A_10, A_11, A_14, C_2, C_7, C_12, C_3, B_9, B_1, B_10, B_13, A_2, A_12, A_15, A_7, C_8, C_9, C_15, C_10, B_14, B_6, B_5, B, A_4, A_5, band, region, AG_arc] MaxLength=10mm
setups:
  Setup1: Magnetostatic MaximumPasses=10 MinimumPasses=2 MinimumConvergedPasses=1 PercentRefinement=30 PercentError=1 NonLinearResidual=0.0001
output variables:
  power = Moving1.Torque*Moving1.Speed
  pos = (Moving1.Position -7.5 * PI/180) * 2 + PI
  sin0 = -sin(pos)
  sin1 = -sin(pos-2*PI/3)
  sin2 = -sin(pos-4*PI/3)
  cos0 = cos(pos)
  cos1 = cos(pos-2*PI/3)
  cos2 = cos(pos-4*PI/3)
  Flux_d = (FluxLinkage(PhaseA)*cos0+FluxLinkage(PhaseB)*cos1+FluxLinkage(PhaseC)*cos2)*2/3
  Flux_q = (FluxLinkage(PhaseA)*sin0+FluxLinkage(PhaseB)*sin1+FluxLinkage(PhaseC)*sin2)*2/3
  I_d = (Current(PhaseA)*cos0 + Current(PhaseB)*cos1 + Current(PhaseC)*cos2)*2/3
  I_q = (Current(PhaseA)*sin0 + Current(PhaseB)*sin1 + Current(PhaseC)*sin2)*2/3
  Irms = sqrt(I_d^2+I_q^2)/sqrt(2)
  Lad = L(PhaseA,PhaseA)*cos0 + L(PhaseA,PhaseB)*cos1 + L(PhaseA,PhaseC)*cos2
  Laq = L(PhaseA,PhaseA)*sin0 + L(PhaseA,PhaseB)*sin1 + L(PhaseA,PhaseC)*sin2
  Lbd = L(PhaseB,PhaseA)*cos0 + L(PhaseB,PhaseB)*cos1 + L(PhaseB,PhaseC)*cos2
  Lbq = L(PhaseB,PhaseA)*sin0 + L(PhaseB,PhaseB)*sin1 + L(PhaseB,PhaseC)*sin2
  Lcd = L(PhaseC,PhaseA)*cos0 + L(PhaseC,PhaseB)*cos1 + L(PhaseC,PhaseC)*cos2
  Lcq = L(PhaseC,PhaseA)*sin0 + L(PhaseC,PhaseB)*sin1 + L(PhaseC,PhaseC)*sin2
  L_d = (Lad*cos0 + Lbd*cos1 + Lcd*cos2) * 2/3
  L_q = (Laq*sin0 + Lbq*sin1 + Lcq*sin2) * 2/3
field calculator expressions:
  b_radial = Fundamental_Quantity(22) | Vector_Function(FuncValueX='0mm', FuncValueY='0mm', FuncValueZ='0mm') | ToCylindrical | ScalarX
field plots:
  Flux_Lines1: A on Setup1 : LastAdaptive
reports:
  Calculator Expressions Plot1: b_radial vs Distance on Setup1 : LastAdaptive

design armature_fileds (Maxwell 2D, Magnetostatic, XY geometry, model units mm)
options: ModelDepth=l
variables:
  d = 96mm
  do = 160mm
  qs = 24
  hs0 = 1mm
  hs1 = 1mm
  hs2 = 14mm
  bs0 = 1mm
  bs1 = 4.7mm
  bs2 = 7mm
  lg = 0.7mm
  dsh = 20mm
  ep = 0.9
  tpm = 4mm
  p = 4
  conductors = 45
  alignment = 7.5deg
  Ns = 1000rpm
  l = 50mm
  iph = 10A
  is = 10*sqrt(2) A
  alpha = 45deg
  skew = 0deg
  Vph_rms = 230V
  RS = 4.07e-05ohm
  ias = ids*conductors
  ics = conductors*(-ids/2-sqrt(3)*iqs/2)
  ibs = conductors*(-ids/2+sqrt(3)*iqs/2)
  ids = is*cos(alpha)
  iqs = is*sin(alpha)
geometry:
  stator [Cogent Power - M250-35A, B-H at 50Hz] = user_primitive(RMxprt/SlotCore.dll, DiaGap=d, DiaYoke=do, Length=0mm, Skew=skew, Slots=qs, SlotType=2, Hs0=hs0, Hs01=0mm, Hs1=hs1, Hs2=hs2, Bs0=bs0, Bs1=bs1, Bs2=bs2, Rs=0mm, FilletType=0, HalfSlot=0, SegAngle=0deg, LenRegion=0mm, InfoCore=0)
  rotor [Cogent Power - M250-35A, B-H at 50Hz] = user_primitive(RMxprt/PMCore.dll, DiaGap=d-2*lg, DiaYoke=dsh, Length=0mm, Poles=p, PoleType=1, Embrace=ep, ThickMag=tpm, WidthMag=0mm, Offset=0mm, Bridge=0mm, Rib=0mm, LenRegion=0mm, InfoCore=0)
  A_3 [copper] = user_primitive(RMxprt/LapCoil.dll, DiaGap=d, DiaYoke=do, Length=0mm, Skew=0deg, Slots=qs, SlotType=2, Hs0=hs0, Hs1=hs1, Hs2=hs2, Bs0=bs0, Bs1=bs1, Bs2=bs2, Rs=0mm, FilletType=0, Layers=2, CoilPitch=6, EndExt=0mm, SpanExt=0mm, BendAngle=0deg, SegAngle=0deg, LenRegion=0mm, InfoCoil=0)
  A, C, C_6, C_14, C_5, B_4, B_7, B_11, B_15, A_6, A_13, A_1, A_9, C_4, C_11, C_13, C_1, B_8, B_12, B_2, B_3, A_8, A_10, A_11, A_14, C_2, C_7, C_12, C_3, B_9, B_1, B_10, B_13, A_2, A_12, A_15, A_7, C_8, C_9, C_15, C_10, B_14, B_6, B_5, B, A_4, A_5 [copper] = A_3.separate_bodies()
  band [vacuum] = polyline((0mm, 0mm, 0mm) (d/2-lg+0.15mm, 0mm, 0mm))
  band.sweep_around_axis(axis=Z, angle=360deg)
  region [vacuum] = circle(normal=Z, centre=(0mm, 0mm, 0mm), radius=do/2+3mm)
  AG_arc = polyline(z=0mm, xy: (d/2-lg/2, 0mm) (-47.648186mm, 0.41581942mm) (47.642743mm, -0.83160717mm), AngularArc from point 0 over 3 centre=(0mm, 0mm, 0mm) angle=359deg plane=XY)
  pm [vacuum] = user_primitive(RMxprt/PMCore.dll, DiaGap=d-2*lg, DiaYoke=dsh, Length=0mm, Poles=p, PoleType=1, Embrace=ep, ThickMag=tpm, WidthMag=0mm, Offset=0mm, Bridge=0mm, Rib=0mm, LenRegion=0mm, InfoCore=1)
  pm_Separate1, pm_Separate2, pm_Separate3 [vacuum] = pm.separate_bodies()
boundaries and excitations:
  VectorPotential1: Vector Potential Edges=region.edge(at (-83, 0, 0)) Value=0
  Current_1: Current Objects=A_12 Current=ias IsPositive=true
  Current_2: Current Objects=A_7 Current=ias IsPositive=true
  Current_3: Current Objects=A_3 Current=ias IsPositive=true
  Current_4: Current Objects=A_4 Current=ias IsPositive=true
  Current_5: Current Objects=A_8 Current=ias IsPositive=true
  Current_6: Current Objects=A_13 Current=ias IsPositive=true
  Current_7: Current Objects=A_9 Current=ias IsPositive=true
  Current_8: Current Objects=A_11 Current=ias IsPositive=true
  Current_9: Current Objects=A_6 Current=ias IsPositive=false
  Current_10: Current Objects=A_5 Current=ias IsPositive=false
  Current_11: Current Objects=A Current=ias IsPositive=false
  Current_12: Current Objects=A_1 Current=ias IsPositive=false
  Current_13: Current Objects=A_2 Current=ias IsPositive=false
  Current_14: Current Objects=A_10 Current=ias IsPositive=false
  Current_15: Current Objects=A_15 Current=ias IsPositive=false
  Current_16: Current Objects=A_14 Current=ias IsPositive=false
  Current_17: Current Objects=C_9 Current=ics IsPositive=false
  Current_18: Current Objects=C Current=ics IsPositive=false
  Current_19: Current Objects=C_10 Current=ics IsPositive=false
  Current_20: Current Objects=C_14 Current=ics IsPositive=false
  Current_21: Current Objects=C_2 Current=ics IsPositive=false
  Current_22: Current Objects=C_11 Current=ics IsPositive=false
  Current_23: Current Objects=C_1 Current=ics IsPositive=false
  Current_24: Current Objects=C_12 Current=ics IsPositive=false
  Current_25: Current Objects=C_13 Current=ics IsPositive=true
  Current_26: Current Objects=C_5 Current=ics IsPositive=true
  Current_27: Current Objects=C_6 Current=ics IsPositive=true
  Current_28: Current Objects=C_4 Current=ics IsPositive=true
  Current_29: Current Objects=C_7 Current=ics IsPositive=true
  Current_30: Current Objects=C_8 Current=ics IsPositive=true
  Current_31: Current Objects=C_15 Current=ics IsPositive=true
  Current_32: Current Objects=C_3 Current=ics IsPositive=true
  Current_33: Current Objects=B Current=ibs IsPositive=true
  Current_34: Current Objects=B_11 Current=ibs IsPositive=true
  Current_35: Current Objects=B_4 Current=ibs IsPositive=true
  Current_36: Current Objects=B_6 Current=ibs IsPositive=true
  Current_37: Current Objects=B_9 Current=ibs IsPositive=true
  Current_38: Current Objects=B_12 Current=ibs IsPositive=true
  Current_39: Current Objects=B_10 Current=ibs IsPositive=true
  Current_40: Current Objects=B_3 Current=ibs IsPositive=true
  Current_41: Current Objects=B_8 Current=ibs IsPositive=false
  Current_42: Current Objects=B_15 Current=ibs IsPositive=false
  Current_43: Current Objects=B_7 Current=ibs IsPositive=false
  Current_44: Current Objects=B_2 Current=ibs IsPositive=false
  Current_45: Current Objects=B_5 Current=ibs IsPositive=false
  Current_46: Current Objects=B_13 Current=ibs IsPositive=false
  Current_47: Current Objects=B_1 Current=ibs IsPositive=false
  Current_48: Current Objects=B_14 Current=ibs IsPositive=false
mesh:
  Length1: LengthBased Edges=AG_arc.edge(at (-47.6482, 0.415819, 0)) band.edge(at (-47.45, 0, 0)) MaxLength=lg
  Length2: LengthBased RefineInside Objects=[stator, rotor, A_3, A, C, C_6, C_14, C_5, B_4, B_7, B_11, B_15, A_6, A_13, A_1, A_9, C_4, C_11, C_13, C_1, B_8, B_12, B_2, B_3, A_8, A_10, A_11, A_14, C_2, C_7, C_12, C_3, B_9, B_1, B_10, B_13, A_2, A_12, A_15, A_7, C_8, C_9, C_15, C_10, B_14, B_6, B_5, B, A_4, A_5, band, region, AG_arc] MaxLength=10mm
setups:
  Setup1: Magnetostatic MaximumPasses=10 MinimumPasses=2 MinimumConvergedPasses=1 PercentRefinement=30 PercentError=1 NonLinearResidual=0.0001
output variables:
  power = Moving1.Torque*Moving1.Speed
  pos = (Moving1.Position -7.5 * PI/180) * 2 + PI
  sin0 = -sin(pos)
  sin1 = -sin(pos-2*PI/3)
  sin2 = -sin(pos-4*PI/3)
  cos0 = cos(pos)
  cos1 = cos(pos-2*PI/3)
  cos2 = cos(pos-4*PI/3)
  Flux_d = (FluxLinkage(PhaseA)*cos0+FluxLinkage(PhaseB)*cos1+FluxLinkage(PhaseC)*cos2)*2/3
  Flux_q = (FluxLinkage(PhaseA)*sin0+FluxLinkage(PhaseB)*sin1+FluxLinkage(PhaseC)*sin2)*2/3
  I_d = (Current(PhaseA)*cos0 + Current(PhaseB)*cos1 + Current(PhaseC)*cos2)*2/3
  I_q = (Current(PhaseA)*sin0 + Current(PhaseB)*sin1 + Current(PhaseC)*sin2)*2/3
  Irms = sqrt(I_d^2+I_q^2)/sqrt(2)
  Lad = L(PhaseA,PhaseA)*cos0 + L(PhaseA,PhaseB)*cos1 + L(PhaseA,PhaseC)*cos2
  Laq = L(PhaseA,PhaseA)*sin0 + L(PhaseA,PhaseB)*sin1 + L(PhaseA,PhaseC)*sin2
  Lbd = L(PhaseB,PhaseA)*cos0 + L(PhaseB,PhaseB)*cos1 + L(PhaseB,PhaseC)*cos2
  Lbq = L(PhaseB,PhaseA)*sin0 + L(PhaseB,PhaseB)*sin1 + L(PhaseB,PhaseC)*sin2
  Lcd = L(PhaseC,PhaseA)*cos0 + L(PhaseC,PhaseB)*cos1 + L(PhaseC,PhaseC)*cos2
  Lcq = L(PhaseC,PhaseA)*sin0 + L(PhaseC,PhaseB)*sin1 + L(PhaseC,PhaseC)*sin2
  L_d = (Lad*cos0 + Lbd*cos1 + Lcd*cos2) * 2/3
  L_q = (Laq*sin0 + Lbq*sin1 + Lcq*sin2) * 2/3
field calculator expressions:
  b_radial = Fundamental_Quantity(22) | Vector_Function(FuncValueX='0mm', FuncValueY='0mm', FuncValueZ='0mm') | ToCylindrical | ScalarX
field plots:
  B_Vector1: B on Setup1 : LastAdaptive
  Flux_Lines1: A on Setup1 : LastAdaptive
reports:
  Calculator Expressions Plot1: b_radial vs Distance on Setup1 : LastAdaptive

design cogging_torque (Maxwell 2D, Transient, XY geometry, model units mm)
options: ComputeTransientInductance ModelDepth=l
variables:
  d = 96mm
  do = 160mm
  qs = 24
  hs0 = 1mm
  hs1 = 1mm
  hs2 = 14mm
  bs0 = 1mm
  bs1 = 4.7mm
  bs2 = 7mm
  lg = 0.7mm
  dsh = 20mm
  ep = 0.9
  tpm = 4mm
  p = 4
  conductors = 42
  alignment = 7.5deg
  Ns = 1000rpm
  l = 50mm
  iph = 10A
  is = 10A
  alpha = 0deg
  skew = 0deg
  Vph_rms = 230V
  RS = 4.07e-05ohm
  kl = 0NewtonMeter
geometry:
  stator [Cogent Power - M250-35A, B-H at 50Hz] = user_primitive(RMxprt/SlotCore.dll, DiaGap=d, DiaYoke=do, Length=0mm, Skew=skew, Slots=qs, SlotType=2, Hs0=hs0, Hs01=0mm, Hs1=hs1, Hs2=hs2, Bs0=bs0, Bs1=bs1, Bs2=bs2, Rs=0mm, FilletType=0, HalfSlot=0, SegAngle=0deg, LenRegion=0mm, InfoCore=0)
  rotor [Cogent Power - M250-35A, B-H at 50Hz] = user_primitive(RMxprt/PMCore.dll, DiaGap=d-2*lg, DiaYoke=dsh, Length=0mm, Poles=p, PoleType=1, Embrace=ep, ThickMag=tpm, WidthMag=0mm, Offset=0mm, Bridge=0mm, Rib=0mm, LenRegion=0mm, InfoCore=0)
  pm [Arnold_Magnetics_N42EH_100C, oriented by FaceCS1] = user_primitive(RMxprt/PMCore.dll, DiaGap=d-2*lg, DiaYoke=dsh, Length=0mm, Poles=4, PoleType=1, Embrace=ep, ThickMag=tpm, WidthMag=0mm, Offset=0mm, Bridge=0mm, Rib=0mm, LenRegion=0mm, InfoCore=2)
  coordinate_system FaceCS1 = face of pm: Origin=(30.617724, 30.617724, 0) FaceID=pm.face(at (28.364, 28.364, 0)) AxisPosn=(33.446151, 33.446151, 0) WhichAxis=X ZRotationAngle=0deg XOffset=0mm YOffset=0mm FaceNormal(0, 0, 1)
  pm_1 [Arnold_Magnetics_N42EH_100C_s, oriented by FaceCS2] = pm.duplicate_around_axis(axis=Z, angle=2*pi/p, total=2)
  coordinate_system FaceCS2 = face of pm_1: Origin=(-30.617724, 30.617724, 0) FaceID=pm_1.face(1 of 1) AxisPosn=(-33.446151, 33.446151, 0) WhichAxis=X ZRotationAngle=0deg XOffset=0mm YOffset=0mm FaceNormal(0, 0, 1)
  pm_2 [Arnold_Magnetics_N42EH_100C, oriented by FaceCS3] = pm.duplicate_around_axis(axis=Z, angle=2*2*pi/p, total=2)
  coordinate_system FaceCS3 = face of pm_2: Origin=(-30.617724, -30.617724, 0) FaceID=pm_2.face(1 of 1) AxisPosn=(-33.446151, -33.446151, 0) WhichAxis=X ZRotationAngle=0deg XOffset=0mm YOffset=0mm FaceNormal(0, 0, 1)
  pm_1_1 [Arnold_Magnetics_N42EH_100C_s, oriented by FaceCS4] = pm_1.duplicate_around_axis(axis=Z, angle=2*2*pi/p, total=2)
  coordinate_system FaceCS4 = face of pm_1_1: Origin=(30.617724, -30.617724, 0) FaceID=pm_1_1.face(1 of 1) AxisPosn=(33.446151, -33.446151, 0) WhichAxis=X ZRotationAngle=0deg XOffset=0mm YOffset=0mm FaceNormal(0, 0, 1)
  A_3 [copper] = user_primitive(RMxprt/LapCoil.dll, DiaGap=d, DiaYoke=do, Length=0mm, Skew=0deg, Slots=qs, SlotType=2, Hs0=hs0, Hs1=hs1, Hs2=hs2, Bs0=bs0, Bs1=bs1, Bs2=bs2, Rs=0mm, FilletType=0, Layers=2, CoilPitch=6, EndExt=0mm, SpanExt=0mm, BendAngle=0deg, SegAngle=0deg, LenRegion=0mm, InfoCoil=0)
  A, C, C_6, C_14, C_5, B_4, B_7, B_11, B_15, A_6, A_13, A_1, A_9, C_4, C_11, C_13, C_1, B_8, B_12, B_2, B_3, A_8, A_10, A_11, A_14, C_2, C_7, C_12, C_3, B_9, B_1, B_10, B_13, A_2, A_12, A_15, A_7, C_8, C_9, C_15, C_10, B_14, B_6, B_5, B, A_4, A_5 [copper] = A_3.separate_bodies()
  band [vacuum] = polyline((0mm, 0mm, 0mm) (d/2-lg+0.15mm, 0mm, 0mm))
  band.sweep_around_axis(axis=Z, angle=360deg)
  region [vacuum] = circle(normal=Z, centre=(0mm, 0mm, 0mm), radius=do/2+3mm)
  AG_arc = polyline(z=0mm, xy: (d/2-lg/2, 0mm) (-47.648186mm, 0.41581942mm) (47.642743mm, -0.83160717mm), AngularArc from point 0 over 3 centre=(0mm, 0mm, 0mm) angle=359deg plane=XY)
motion:
  MotionSetup1: Band Move_Type=Rotate Coordinate_System=Global Axis=Z Is_Positive=true InitPos=alignment Angular_Velocity=1500rpm Objects=band
  Moving1: Moving Objects=[rotor, pm, pm_1, pm_2, pm_1_1]
boundaries and excitations:
  VectorPotential1: Vector Potential Edges=region.edge(at (-83, 0, 0)) Value=0
  eddy effects on: pm, pm_1, pm_2, pm_1_1
  core loss on: stator, rotor
mesh:
  CylindricalGap1: CylindricalGap Objects=band Objects=band
setups:
  dynamic: Transient NonlinearSolverResidual=0.0001 StopTime=200ms TimeStep=1ms SaveFieldsType="Every N Steps" N_Steps=1 Steps_From=2ms Steps_To=200ms NumberSolveSteps=1 RangeStart=0s RangeEnd=0.1s InitialTimeStep=0.002s MinTimeStep=0.001s MaxTimeStep=0.003s TimeStepErrTolerance=0.0001
optimetrics:
  ParametricSetup1: Parametric InterpolationPoints=0 Sim._Setups=[dynamic]
    sweep kl: 0NewtonMeter
output variables:
  power = Moving1.Torque*Moving1.Speed
  pos = (Moving1.Position -7.5 * PI/180) * 2 + PI
  sin0 = -sin(pos)
  sin1 = -sin(pos-2*PI/3)
  sin2 = -sin(pos-4*PI/3)
  cos0 = cos(pos)
  cos1 = cos(pos-2*PI/3)
  cos2 = cos(pos-4*PI/3)
  Flux_d = (FluxLinkage(PhaseA)*cos0+FluxLinkage(PhaseB)*cos1+FluxLinkage(PhaseC)*cos2)*2/3
  Flux_q = (FluxLinkage(PhaseA)*sin0+FluxLinkage(PhaseB)*sin1+FluxLinkage(PhaseC)*sin2)*2/3
  I_d = (Current(PhaseA)*cos0 + Current(PhaseB)*cos1 + Current(PhaseC)*cos2)*2/3
  I_q = (Current(PhaseA)*sin0 + Current(PhaseB)*sin1 + Current(PhaseC)*sin2)*2/3
  Irms = sqrt(I_d^2+I_q^2)/sqrt(2)
  Lad = L(PhaseA,PhaseA)*cos0 + L(PhaseA,PhaseB)*cos1 + L(PhaseA,PhaseC)*cos2
  Laq = L(PhaseA,PhaseA)*sin0 + L(PhaseA,PhaseB)*sin1 + L(PhaseA,PhaseC)*sin2
  Lbd = L(PhaseB,PhaseA)*cos0 + L(PhaseB,PhaseB)*cos1 + L(PhaseB,PhaseC)*cos2
  Lbq = L(PhaseB,PhaseA)*sin0 + L(PhaseB,PhaseB)*sin1 + L(PhaseB,PhaseC)*sin2
  Lcd = L(PhaseC,PhaseA)*cos0 + L(PhaseC,PhaseB)*cos1 + L(PhaseC,PhaseC)*cos2
  Lcq = L(PhaseC,PhaseA)*sin0 + L(PhaseC,PhaseB)*sin1 + L(PhaseC,PhaseC)*sin2
  L_d = (Lad*cos0 + Lbd*cos1 + Lcd*cos2) * 2/3
  L_q = (Laq*sin0 + Lbq*sin1 + Lcq*sin2) * 2/3
field calculator expressions:
  Bradial = Fundamental_Quantity(22) | ScalarX | Scalar_Function(FuncValue='PHI') | UMathFunc | * | Fundamental_Quantity(22) | ScalarY | Scalar_Function(FuncValue='PHI') | UMathFunc | * | +
field plots:
  Flux_Lines1: A on dynamic : Transient at Time=2ms
reports:
  Torque Plot1: Moving1.Torque vs Time on dynamic : Transient [kl=all]

design new (Maxwell 2D, Transient, XY geometry, model units mm)
options: ComputeTransientInductance ModelDepth=l
variables:
  d = 96mm
  do = 160mm
  qs = 24
  hs0 = 1mm
  hs1 = 1mm
  hs2 = 14mm
  bs0 = 1mm
  bs1 = 4.7mm
  bs2 = 7mm
  lg = 0.7mm
  dsh = 20mm
  ep = 0.9
  tpm = 4mm
  p = 4
  conductors = 42
  alignment = 7.5deg
  Ns = 1000rpm
  l = 50mm
  iph = 10A
  is = 10A
  alpha = 0deg
  skew = 0deg
  Vph_rms = 230V
  RS = 4.07e-05ohm
  kl = 0NewtonMeter
geometry:
  stator [Cogent Power - M250-35A, B-H at 50Hz] = user_primitive(RMxprt/SlotCore.dll, DiaGap=d, DiaYoke=do, Length=0mm, Skew=skew, Slots=qs, SlotType=2, Hs0=hs0, Hs01=0mm, Hs1=hs1, Hs2=hs2, Bs0=bs0, Bs1=bs1, Bs2=bs2, Rs=0mm, FilletType=0, HalfSlot=0, SegAngle=0deg, LenRegion=0mm, InfoCore=0)
  rotor [Cogent Power - M250-35A, B-H at 50Hz] = user_primitive(RMxprt/PMCore.dll, DiaGap=d-2*lg, DiaYoke=dsh, Length=0mm, Poles=p, PoleType=1, Embrace=ep, ThickMag=tpm, WidthMag=0mm, Offset=0mm, Bridge=0mm, Rib=0mm, LenRegion=0mm, InfoCore=0)
  pm [Arnold_Magnetics_N42EH_100C, oriented by FaceCS1] = user_primitive(RMxprt/PMCore.dll, DiaGap=d-2*lg, DiaYoke=dsh, Length=0mm, Poles=4, PoleType=1, Embrace=ep, ThickMag=tpm, WidthMag=0mm, Offset=0mm, Bridge=0mm, Rib=0mm, LenRegion=0mm, InfoCore=2)
  coordinate_system FaceCS1 = face of pm: Origin=(30.617724, 30.617724, 0) FaceID=pm.face(at (28.364, 28.364, 0)) AxisPosn=(33.446151, 33.446151, 0) WhichAxis=X ZRotationAngle=0deg XOffset=0mm YOffset=0mm FaceNormal(0, 0, 1)
  pm_1 [Arnold_Magnetics_N42EH_100C_s, oriented by FaceCS2] = pm.duplicate_around_axis(axis=Z, angle=2*pi/p, total=2)
  coordinate_system FaceCS2 = face of pm_1: Origin=(-30.617724, 30.617724, 0) FaceID=pm_1.face(1 of 1) AxisPosn=(-33.446151, 33.446151, 0) WhichAxis=X ZRotationAngle=0deg XOffset=0mm YOffset=0mm FaceNormal(0, 0, 1)
  pm_2 [Arnold_Magnetics_N42EH_100C, oriented by FaceCS3] = pm.duplicate_around_axis(axis=Z, angle=2*2*pi/p, total=2)
  coordinate_system FaceCS3 = face of pm_2: Origin=(-30.617724, -30.617724, 0) FaceID=pm_2.face(1 of 1) AxisPosn=(-33.446151, -33.446151, 0) WhichAxis=X ZRotationAngle=0deg XOffset=0mm YOffset=0mm FaceNormal(0, 0, 1)
  pm_1_1 [Arnold_Magnetics_N42EH_100C_s, oriented by FaceCS4] = pm_1.duplicate_around_axis(axis=Z, angle=2*2*pi/p, total=2)
  coordinate_system FaceCS4 = face of pm_1_1: Origin=(30.617724, -30.617724, 0) FaceID=pm_1_1.face(1 of 1) AxisPosn=(33.446151, -33.446151, 0) WhichAxis=X ZRotationAngle=0deg XOffset=0mm YOffset=0mm FaceNormal(0, 0, 1)
  A_3 [copper] = user_primitive(RMxprt/LapCoil.dll, DiaGap=d, DiaYoke=do, Length=0mm, Skew=0deg, Slots=qs, SlotType=2, Hs0=hs0, Hs1=hs1, Hs2=hs2, Bs0=bs0, Bs1=bs1, Bs2=bs2, Rs=0mm, FilletType=0, Layers=2, CoilPitch=6, EndExt=0mm, SpanExt=0mm, BendAngle=0deg, SegAngle=0deg, LenRegion=0mm, InfoCoil=0)
  A, C, C_6, C_14, C_5, B_4, B_7, B_11, B_15, A_6, A_13, A_1, A_9, C_4, C_11, C_13, C_1, B_8, B_12, B_2, B_3, A_8, A_10, A_11, A_14, C_2, C_7, C_12, C_3, B_9, B_1, B_10, B_13, A_2, A_12, A_15, A_7, C_8, C_9, C_15, C_10, B_14, B_6, B_5, B, A_4, A_5 [copper] = A_3.separate_bodies()
  band [vacuum] = polyline((0mm, 0mm, 0mm) (d/2-lg+0.15mm, 0mm, 0mm))
  band.sweep_around_axis(axis=Z, angle=360deg)
  region [vacuum] = circle(normal=Z, centre=(0mm, 0mm, 0mm), radius=do/2+3mm)
  AG_arc = polyline(z=0mm, xy: (d/2-lg/2, 0mm) (-47.648186mm, 0.41581942mm) (47.642743mm, -0.83160717mm), AngularArc from point 0 over 3 centre=(0mm, 0mm, 0mm) angle=359deg plane=XY)
motion:
  MotionSetup1: Band Move_Type=Rotate Coordinate_System=Global Axis=Z Is_Positive=true InitPos=alignment Angular_Velocity=0rpm Objects=band
  Moving1: Moving Objects=[rotor, pm, pm_1, pm_2, pm_1_1]
boundaries and excitations:
  VectorPotential1: Vector Potential Edges=region.edge(at (-83, 0, 0)) Value=0
  A_7: Coil Objects=A_7 Conductor_number=conductors Winding=PhaseA PolarityType=Positive
  A_3: Coil Objects=A_3 Conductor_number=conductors Winding=PhaseA PolarityType=Positive
  A_4: Coil Objects=A_4 Conductor_number=conductors Winding=PhaseA PolarityType=Positive
  A_12: Coil Objects=A_12 Conductor_number=conductors Winding=PhaseA PolarityType=Positive
  A_8: Coil Objects=A_8 Conductor_number=conductors Winding=PhaseA PolarityType=Positive
  A_13: Coil Objects=A_13 Conductor_number=conductors Winding=PhaseA PolarityType=Positive
  A_9: Coil Objects=A_9 Conductor_number=conductors Winding=PhaseA PolarityType=Positive
  A_11: Coil Objects=A_11 Conductor_number=conductors Winding=PhaseA PolarityType=Positive
  A_6: Coil Objects=A_6 Conductor_number=conductors Winding=PhaseA PolarityType=Negative
  A_5: Coil Objects=A_5 Conductor_number=conductors Winding=PhaseA PolarityType=Negative
  A: Coil Objects=A Conductor_number=conductors Winding=PhaseA PolarityType=Negative
  A_1: Coil Objects=A_1 Conductor_number=conductors Winding=PhaseA PolarityType=Negative
  A_2: Coil Objects=A_2 Conductor_number=conductors Winding=PhaseA PolarityType=Negative
  A_15: Coil Objects=A_15 Conductor_number=conductors Winding=PhaseA PolarityType=Negative
  A_10: Coil Objects=A_10 Conductor_number=conductors Winding=PhaseA PolarityType=Negative
  A_14: Coil Objects=A_14 Conductor_number=conductors Winding=PhaseA PolarityType=Negative
  C: Coil Objects=C Conductor_number=conductors Winding=PhaseC PolarityType=Negative
  C_9: Coil Objects=C_9 Conductor_number=conductors Winding=PhaseC PolarityType=Negative
  C_10: Coil Objects=C_10 Conductor_number=conductors Winding=PhaseC PolarityType=Negative
  C_14: Coil Objects=C_14 Conductor_number=conductors Winding=PhaseC PolarityType=Negative
  C_2: Coil Objects=C_2 Conductor_number=conductors Winding=PhaseC PolarityType=Negative
  C_11: Coil Objects=C_11 Conductor_number=conductors Winding=PhaseC PolarityType=Negative
  C_1: Coil Objects=C_1 Conductor_number=conductors Winding=PhaseC PolarityType=Negative
  C_12: Coil Objects=C_12 Conductor_number=conductors Winding=PhaseC PolarityType=Negative
  C_6: Coil Objects=C_6 Conductor_number=conductors Winding=PhaseC PolarityType=Positive
  C_4: Coil Objects=C_4 Conductor_number=conductors Winding=PhaseC PolarityType=Positive
  C_5: Coil Objects=C_5 Conductor_number=conductors Winding=PhaseC PolarityType=Positive
  C_13: Coil Objects=C_13 Conductor_number=conductors Winding=PhaseC PolarityType=Positive
  C_8: Coil Objects=C_8 Conductor_number=conductors Winding=PhaseC PolarityType=Positive
  C_15: Coil Objects=C_15 Conductor_number=conductors Winding=PhaseC PolarityType=Positive
  C_3: Coil Objects=C_3 Conductor_number=conductors Winding=PhaseC PolarityType=Positive
  C_7: Coil Objects=C_7 Conductor_number=conductors Winding=PhaseC PolarityType=Positive
  B: Coil Objects=B Conductor_number=conductors Winding=PhaseB PolarityType=Positive
  B_11: Coil Objects=B_11 Conductor_number=conductors Winding=PhaseB PolarityType=Positive
  B_4: Coil Objects=B_4 Conductor_number=conductors Winding=PhaseB PolarityType=Positive
  B_6: Coil Objects=B_6 Conductor_number=conductors Winding=PhaseB PolarityType=Positive
  B_9: Coil Objects=B_9 Conductor_number=conductors Winding=PhaseB PolarityType=Positive
  B_12: Coil Objects=B_12 Conductor_number=conductors Winding=PhaseB PolarityType=Positive
  B_10: Coil Objects=B_10 Conductor_number=conductors Winding=PhaseB PolarityType=Positive
  B_3: Coil Objects=B_3 Conductor_number=conductors Winding=PhaseB PolarityType=Positive
  B_2: Coil Objects=B_2 Conductor_number=conductors Winding=PhaseB PolarityType=Negative
  B_15: Coil Objects=B_15 Conductor_number=conductors Winding=PhaseB PolarityType=Negative
  B_7: Coil Objects=B_7 Conductor_number=conductors Winding=PhaseB PolarityType=Negative
  B_8: Coil Objects=B_8 Conductor_number=conductors Winding=PhaseB PolarityType=Negative
  B_14: Coil Objects=B_14 Conductor_number=conductors Winding=PhaseB PolarityType=Negative
  B_1: Coil Objects=B_1 Conductor_number=conductors Winding=PhaseB PolarityType=Negative
  B_5: Coil Objects=B_5 Conductor_number=conductors Winding=PhaseB PolarityType=Negative
  B_13: Coil Objects=B_13 Conductor_number=conductors Winding=PhaseB PolarityType=Negative
  PhaseA: Winding Group Type=Voltage IsSolid=false Current=0 Resistance=1.5ohm Inductance=0nH Voltage=1.41*Vph_rms*sin(2*pi*50*time) ParallelBranchesNum=1
  PhaseB: Winding Group Type=Voltage IsSolid=false Current=0 Resistance=1.5ohm Inductance=0nH Voltage=1.41*Vph_rms*sin(2*pi*50*time-2*pi/3) ParallelBranchesNum=1
  PhaseC: Winding Group Type=Voltage IsSolid=false Current=0 Resistance=1.5ohm Inductance=0nH Voltage=1.41*Vph_rms*sin(2*pi*50*time-4*pi/3) ParallelBranchesNum=1
  eddy effects on: pm, pm_1, pm_2, pm_1_1
  core loss on: stator, rotor
mesh:
  CylindricalGap1: CylindricalGap Objects=band Objects=band
setups:
  dynamic: Transient NonlinearSolverResidual=0.0001 StopTime=400ms TimeStep=1ms SaveFieldsType="Every N Steps" N_Steps=1 Steps_From=2ms Steps_To=200ms NumberSolveSteps=1 RangeStart=0s RangeEnd=0.1s InitialTimeStep=0.002s MinTimeStep=0.001s MaxTimeStep=0.003s TimeStepErrTolerance=0.0001
optimetrics:
  ParametricSetup1: Parametric InterpolationPoints=0 Sim._Setups=[dynamic]
    sweep kl: 0NewtonMeter
output variables:
  power = Moving1.Torque*Moving1.Speed
  pos = (Moving1.Position -7.5 * PI/180) * 2 + PI
  sin0 = -sin(pos)
  sin1 = -sin(pos-2*PI/3)
  sin2 = -sin(pos-4*PI/3)
  cos0 = cos(pos)
  cos1 = cos(pos-2*PI/3)
  cos2 = cos(pos-4*PI/3)
  Flux_d = (FluxLinkage(PhaseA)*cos0+FluxLinkage(PhaseB)*cos1+FluxLinkage(PhaseC)*cos2)*2/3
  Flux_q = (FluxLinkage(PhaseA)*sin0+FluxLinkage(PhaseB)*sin1+FluxLinkage(PhaseC)*sin2)*2/3
  I_d = (Current(PhaseA)*cos0 + Current(PhaseB)*cos1 + Current(PhaseC)*cos2)*2/3
  I_q = (Current(PhaseA)*sin0 + Current(PhaseB)*sin1 + Current(PhaseC)*sin2)*2/3
  Irms = sqrt(I_d^2+I_q^2)/sqrt(2)
  Lad = L(PhaseA,PhaseA)*cos0 + L(PhaseA,PhaseB)*cos1 + L(PhaseA,PhaseC)*cos2
  Laq = L(PhaseA,PhaseA)*sin0 + L(PhaseA,PhaseB)*sin1 + L(PhaseA,PhaseC)*sin2
  Lbd = L(PhaseB,PhaseA)*cos0 + L(PhaseB,PhaseB)*cos1 + L(PhaseB,PhaseC)*cos2
  Lbq = L(PhaseB,PhaseA)*sin0 + L(PhaseB,PhaseB)*sin1 + L(PhaseB,PhaseC)*sin2
  Lcd = L(PhaseC,PhaseA)*cos0 + L(PhaseC,PhaseB)*cos1 + L(PhaseC,PhaseC)*cos2
  Lcq = L(PhaseC,PhaseA)*sin0 + L(PhaseC,PhaseB)*sin1 + L(PhaseC,PhaseC)*sin2
  L_d = (Lad*cos0 + Lbd*cos1 + Lcd*cos2) * 2/3
  L_q = (Laq*sin0 + Lbq*sin1 + Lcq*sin2) * 2/3
field calculator expressions:
  Bradial = Fundamental_Quantity(22) | ScalarX | Scalar_Function(FuncValue='PHI') | UMathFunc | * | Fundamental_Quantity(22) | ScalarY | Scalar_Function(FuncValue='PHI') | UMathFunc | * | +
reports:
  Torque Plot1: Moving1.Torque vs Time on dynamic : Transient [kl=all]
  Speed Plot1: Moving1.Speed vs Time on dynamic : Transient [kl=all]
  Winding Plot1: InducedVoltage(PhaseA) vs Time on dynamic : Transient [kl=all]
  Winding Plot2: Current(PhaseA) vs Time on dynamic : Transient [kl=all]

design Simplorer2 (Twin Builder)
components:
  FEA1 = MxTranTranData3(Maxwell_Host=DHANUNJAY Maxwell_HostPort=7779 ComponentDataType=MxTranTranData name=MxTranTranData3 filename=$PROJECTDIR\full.aedt numberofports=8 CouplingDesignName=Maxwell2DDesign1 CouplingSolutionName="dynamic : Transient" CouplingMatrixName="dynamic : Transient" CouplingType=ExtCircuit2DLink ModelText='SMLDEF MxTranTranData3 / { / PORT ELECTRICAL: T1; / PORT ELECTRICAL: T2; / PORT ELECTRICAL: T3; / PORT ROTATIONAL: T4; / PORT ELECTRICAL: T5; / PORT ELECTRICAL: T6; / PORT ELECTRICAL: T7; / PORT ROTATIONAL: T8; / PORT string in: Maxwell_Host; / PORT string in: Maxwell_HostPort; / PORT real out: WIRELOSS = MAXWELL.VEC[0]; / PORT real out: CORELOSS = MAXWELL.VEC[1]; / PORT real out CURRENT: IT1 = MAXWELL.VEC[2]; / PORT real out VOLTAGE: VT1 = MAXWELL.VEC[3]; / PORT real out VOLTAGE: EIT1 = MAXWELL.VEC[4]; / PORT real out MAGNETIC_FLUX: FLUXT1 = MAXWELL.VEC[5]; / PORT real out CURRENT: IT2 = MAXWELL.VEC[6]; / PORT real out VOLTAGE: VT2 = MAXWELL.VEC[7]; / PORT real out VOLTAGE: EIT2 = MAXWELL.VEC[8]; / PORT real out MAGNETIC_FLUX: FLUXT2 = MAXWELL.VEC[9]; / PORT real out CURRENT: IT3 = MAXWELL.VEC[10]; / PORT real out VOLTAGE: VT3 = MAXWELL.VEC[11]; / PORT real out VOLTAGE: EIT3 = MAXWELL.VEC[12]; / PORT real out MAGNETIC_FLUX: FLUXT3 = MAXWELL.VEC[13]; / PORT real out: TORQUE = MAXWELL.VEC[14]; / PORT real out: PHI = MAXWELL.VEC[15]; / PORT real out: OMEGA = MAXWELL.VEC[16]; / PORT real out: FEA_STEPS = MAXWELL.VEC[17]; / UMODEL FEA_LINK MAXWELL N0:=T1,N1:=T5,N2:=T2,N3:=T6,N4:)
  AM2 = AM(I=0)
  AM1 = AM(I=0)
  AM3 = AM(I=0)
  E1 = E(EMF=600V PERIO=0)
  V_ROTB1 = V_ROTB(PERIO=0 VALUE=1000rpm PHI0=7.5deg)
  FM_ROTB1 = FM_ROTB()
  VM_ROTB1 = VM_ROTB()
  SM_ROTB1 = SM_ROTB(PHI=0)
  R1 = R(R=50mOhm)
  R2 = R(R=50mOhm)
  R3 = R(R=50mOhm)
  L1 = L()
  L2 = L()
  L3 = L()
  sum1 = sum(input0=SM_ROTB1.PHI input1=7.5*pi/180)
  GAIN1 = GAIN(INPUT=sum1.val KP=2*pi)
  abc2dq0_1 = abc2dq0(phi_e=GAIN1.VAL i_a=AM2.I i_b=AM1.I i_c=AM3.I i_0=0)
  PI_1 = PI_(IN=abc2dq0_1.i_d SET=0 LL=-400 LL_I=-200 UL=400 UL_I=200)
  PI_2 = PI_(IN=abc2dq0_1.i_q SET=10 LL=-400 LL_I=-200 UL=400 UL_I=200)
  dq02abz1 = dq02abz(phi_e=GAIN1.VAL d=PI_1.VAL q=PI_2.VAL zero=0)
  svpwm1 = svpwm(SimulatorModel="Simplorer Elements\Power System VHDLAMS\Power System VHDLAMS:svpwm - mid_align,Simplorer Elements\Power System VHDLAMS\Power System VHDLAMS:svpwm - right_align,Simplorer Elements\Power System VHDLAMS\Power System VHDLAMS:svpwm - left_align" dead_time=1e-06 v_alpha=dq02abz1.alpha v_beta=dq02abz1.beta t1=0 t2=0 t3=0 t4=0 t5=0 t6=0 v_dc=600)
  tprc1 = tprc(ctrl11=svpwm1.t1 ctrl12=svpwm1.t2 ctrl21=svpwm1.t3 ctrl22=svpwm1.t4 ctrl31=svpwm1.t5 ctrl32=svpwm1.t6)
nets:
  0: FEA1.T8
  net_20: V_ROTB1.0, FM_ROTB1.1
  net_21: FM_ROTB1.0, FEA1.T4, SM_ROTB1.0, VM_ROTB1.0
  net_22: sum1.input0, SM_ROTB1.PHI
  net_23: GAIN1.INPUT, sum1.val
  net_24: GAIN1.VAL, abc2dq0_1.phi_e, dq02abz1.phi_e
  net_25: AM1.1, R2.0
  net_26: AM3.1, R3.0
  net_27: AM2.1, R1.0
  net_28: L1.0, R1.1
  net_29: R2.1, L2.0
  net_30: L3.0, R3.1
  net_53: AM2.0, tprc1.2
  net_54: FEA1.T1, L1.1
  net_56: FEA1.T2, L2.1
  net_57: FEA1.T3, L3.1
  net_58: AM3.0, tprc1.4
  net_59: E1.1, tprc1.0
  net_61: AM1.0, tprc1.3
  net_64: E1.0, tprc1.1
  net_65: FEA1.T5, FEA1.T6, FEA1.T7
  net_66: AM2.I, abc2dq0_1.i_a
  net_67: AM1.I, abc2dq0_1.i_b
  net_68: AM3.I, abc2dq0_1.i_c
  net_69: abc2dq0_1.i_d, PI_1.IN
  net_70: abc2dq0_1.i_q, PI_2.IN
  net_71: PI_1.VAL, dq02abz1.d
  net_72: dq02abz1.q, PI_2.VAL
  net_73: svpwm1.v_alpha, dq02abz1.alpha
  net_74: svpwm1.v_beta, dq02abz1.beta
setups:
  TR: TransientData(80ms, 0.1ms, 0.2ms, false, "")
reports:
  XY Plot1: SM_ROTB1.PHI vs Time on TR : TR
  XY Plot2: VM_ROTB1.OMEGA vs Time on TR : TR
